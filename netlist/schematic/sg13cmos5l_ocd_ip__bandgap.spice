** sch_path: /home/tim/gits/sg13cmos5l_ocd_ip__biasgen/xschem/sg13cmos5l_ocd_ip__bandgap.sch
.subckt sg13cmos5l_ocd_ip__bandgap vdd vbg vss ibias1_250n trim[15] trim[14] trim[13] trim[12] trim[11] trim[10] trim[9] trim[8]
+ trim[7] trim[6] trim[5] trim[4] trim[3] trim[2] trim[1] trim[0] dvss dvdd ena ibias2_1u
*.PININFO trim[15:0]:I ena:I vbg:O ibias2_1u:B ibias1_250n:B vdd:B dvdd:B dvss:B vss:B
x1 vdd vbg_unbuf vss ibias1_250n trim[15] trim[14] trim[13] trim[12] trim[11] trim[10] trim[9] trim[8] trim[7] trim[6] trim[5]
+ trim[4] trim[3] trim[2] trim[1] trim[0] dvss dvdd ena ena_b_h bandgap_unbuffered
x2 vdd vbg vbg_unbuf vbg vss ibias2_1u ena_b_h se_folded_cascode_np_ab
.ends

* expanding   symbol:  bandgap_unbuffered.sym # of pins=9
** sym_path: /home/tim/gits/sg13cmos5l_ocd_ip__biasgen/xschem/bandgap_unbuffered.sym
** sch_path: /home/tim/gits/sg13cmos5l_ocd_ip__biasgen/xschem/bandgap_unbuffered.sch
.subckt bandgap_unbuffered vdd vbg vss bias trim[15] trim[14] trim[13] trim[12] trim[11] trim[10] trim[9] trim[8] trim[7] trim[6]
+ trim[5] trim[4] trim[3] trim[2] trim[1] trim[0] dvss dvdd ena ena_b_h
*.PININFO vdd:B vss:B vbg:O bias:B trim[15:0]:I dvss:B dvdd:B ena:I ena_b_h:O
XQ2 vss vss net2 pnpMPA a=1.4e-12 p=5.4e-06 m=8
XQ1 vss vss vn pnpMPA a=1.4e-12 p=5.4e-06 m=1
C1 gate vss 1.69p m=1
xres vbg comp vp vn vss net1 vss vss vp vss vss bg_res
XM1 comp gate vdd vdd sg13_hv_pmos w=4u l=1u ng=1 m=2
XM2 vbg gate vdd vdd sg13_hv_pmos w=4u l=1u ng=1 m=2
xtr net1 net2 net4[15] net4[14] net4[13] net4[12] net4[11] net4[10] net4[9] net4[8] net4[7] net4[6] net4[5] net4[4] net4[3]
+ net4[2] net4[1] net4[0] vss bg_trim
xamp vdd gate vp vn vss bias ena_b_h se_folded_cascode_p
XM3 vs1 vbg vss vss sg13_hv_nmos w=1u l=1u ng=1 m=1
XM4 gate vs1 vss vss sg13_hv_nmos w=1u l=1u ng=1 m=1
XM5 vs1 vs2 vdd vdd sg13_hv_pmos w=1u l=1u ng=1 m=1
C2 vs2 vss 440.32f m=1
XM6 vs2 vs2 vdd vdd sg13_hv_pmos w=1u l=1u ng=1 m=1
XM7 vss vdd vs2 vs2 sg13_hv_pmos w=1u l=1u ng=1 m=1
x1[15] net3[15] trim[15] net4[15] vdd vss level_shift
x1[14] net3[14] trim[14] net4[14] vdd vss level_shift
x1[13] net3[13] trim[13] net4[13] vdd vss level_shift
x1[12] net3[12] trim[12] net4[12] vdd vss level_shift
x1[11] net3[11] trim[11] net4[11] vdd vss level_shift
x1[10] net3[10] trim[10] net4[10] vdd vss level_shift
x1[9] net3[9] trim[9] net4[9] vdd vss level_shift
x1[8] net3[8] trim[8] net4[8] vdd vss level_shift
x1[7] net3[7] trim[7] net4[7] vdd vss level_shift
x1[6] net3[6] trim[6] net4[6] vdd vss level_shift
x1[5] net3[5] trim[5] net4[5] vdd vss level_shift
x1[4] net3[4] trim[4] net4[4] vdd vss level_shift
x1[3] net3[3] trim[3] net4[3] vdd vss level_shift
x1[2] net3[2] trim[2] net4[2] vdd vss level_shift
x1[1] net3[1] trim[1] net4[1] vdd vss level_shift
x1[0] net3[0] trim[0] net4[0] vdd vss level_shift
x2[15] net3[15] trim[15] dvdd dvss sg13cmos5l_inv_2
x2[14] net3[14] trim[14] dvdd dvss sg13cmos5l_inv_2
x2[13] net3[13] trim[13] dvdd dvss sg13cmos5l_inv_2
x2[12] net3[12] trim[12] dvdd dvss sg13cmos5l_inv_2
x2[11] net3[11] trim[11] dvdd dvss sg13cmos5l_inv_2
x2[10] net3[10] trim[10] dvdd dvss sg13cmos5l_inv_2
x2[9] net3[9] trim[9] dvdd dvss sg13cmos5l_inv_2
x2[8] net3[8] trim[8] dvdd dvss sg13cmos5l_inv_2
x2[7] net3[7] trim[7] dvdd dvss sg13cmos5l_inv_2
x2[6] net3[6] trim[6] dvdd dvss sg13cmos5l_inv_2
x2[5] net3[5] trim[5] dvdd dvss sg13cmos5l_inv_2
x2[4] net3[4] trim[4] dvdd dvss sg13cmos5l_inv_2
x2[3] net3[3] trim[3] dvdd dvss sg13cmos5l_inv_2
x2[2] net3[2] trim[2] dvdd dvss sg13cmos5l_inv_2
x2[1] net3[1] trim[1] dvdd dvss sg13cmos5l_inv_2
x2[0] net3[0] trim[0] dvdd dvss sg13cmos5l_inv_2
x3 ena net5 ena_b_h vdd vss level_shift
x4 net5 ena dvdd dvss sg13cmos5l_inv_2
x3[4] dvdd dvss sg13cmos5l_decap_4
x3[3] dvdd dvss sg13cmos5l_decap_4
x3[2] dvdd dvss sg13cmos5l_decap_4
x3[1] dvdd dvss sg13cmos5l_decap_4
x3[0] dvdd dvss sg13cmos5l_decap_4
x1 ena dvdd dvss sg13cmos5l_antennanp
x4[15] trim[15] dvdd dvss sg13cmos5l_antennanp
x4[14] trim[14] dvdd dvss sg13cmos5l_antennanp
x4[13] trim[13] dvdd dvss sg13cmos5l_antennanp
x4[12] trim[12] dvdd dvss sg13cmos5l_antennanp
x4[11] trim[11] dvdd dvss sg13cmos5l_antennanp
x4[10] trim[10] dvdd dvss sg13cmos5l_antennanp
x4[9] trim[9] dvdd dvss sg13cmos5l_antennanp
x4[8] trim[8] dvdd dvss sg13cmos5l_antennanp
x4[7] trim[7] dvdd dvss sg13cmos5l_antennanp
x4[6] trim[6] dvdd dvss sg13cmos5l_antennanp
x4[5] trim[5] dvdd dvss sg13cmos5l_antennanp
x4[4] trim[4] dvdd dvss sg13cmos5l_antennanp
x4[3] trim[3] dvdd dvss sg13cmos5l_antennanp
x4[2] trim[2] dvdd dvss sg13cmos5l_antennanp
x4[1] trim[1] dvdd dvss sg13cmos5l_antennanp
x4[0] trim[0] dvdd dvss sg13cmos5l_antennanp
C3 vs2 vss 203.19f m=1
.ends

* expanding   symbol:  se_folded_cascode_np_ab.sym # of pins=7
** sym_path: /home/tim/gits/sg13cmos5l_ocd_ip__biasgen/xschem/se_folded_cascode_np_ab.sym
** sch_path: /home/tim/gits/sg13cmos5l_ocd_ip__biasgen/xschem/se_folded_cascode_np_ab.sch
.subckt se_folded_cascode_np_ab vdd out inp inn vss bias ena_b
*.PININFO vdd:B bias:B inp:I inn:I vss:B out:O ena_b:I
XM4 outa1n outa1n vdd vdd sg13_hv_pmos w=1u l=1u ng=1 m=12
XM5 outa1p outa1n vdd vdd sg13_hv_pmos w=1u l=1u ng=1 m=12
XMIN1 diffa vbn1 vss vss sg13_hv_nmos w=1u l=1u ng=1 m=8
XMB2 vbn1 vbn1 vss vss sg13_hv_nmos w=1u l=1u ng=1 m=4
XMB1 vbn2 vbn2 vbn1 vss sg13_hv_nmos w=2u l=4u ng=1 m=4
XMIN2 outa1n inn diffa vss sg13_hv_nmos w=2u l=1u ng=1 m=8
XMIN3 outa1p inp diffa vss sg13_hv_nmos w=2u l=1u ng=1 m=8
XMB5 vbp1 vbp1 vdd vdd sg13_hv_pmos w=1u l=1u ng=1 m=4
XM7 outs1 mirr outa1p vdd sg13_hv_pmos w=1u l=4u ng=1 m=16
XM6 mirr mirr outa1n vdd sg13_hv_pmos w=1u l=4u ng=1 m=16
XM8 mirr vbn2 outb1n vss sg13_hv_nmos w=2u l=4u ng=1 m=16
XM9 outs1 vbn2 outb1p vss sg13_hv_nmos w=2u l=4u ng=1 m=16
XM10 outb1n vbn1 vss vss sg13_hv_nmos w=1u l=1u ng=1 m=24
XM11 outb1p vbn1 vss vss sg13_hv_nmos w=1u l=1u ng=1 m=24
XMB4 net1 net1 vbp1 vdd sg13_hv_pmos w=1u l=4u ng=1 m=4
XMIP2 outb1n inn diffb vdd sg13_hv_pmos w=4u l=1u ng=1 m=8
XMIP3 outb1p inp diffb vdd sg13_hv_pmos w=4u l=1u ng=1 m=8
XMIP1 diffb vbp1 vdd vdd sg13_hv_pmos w=1u l=1u ng=1 m=16
XMON out outs1 vss vss sg13_hv_nmos w=4u l=4u ng=1 m=4
XMOP out outs1 vdd vdd sg13_hv_pmos w=4u l=4u ng=1 m=4
C1[1] out outs1 1.30p m=1
C1[0] out outs1 1.30p m=1
XMB6 vbn2 vbp1 vdd vdd sg13_hv_pmos w=1u l=1u ng=1 m=4
XMB3 bias ena_b net1 vdd sg13_hv_pmos w=1u l=4u ng=1 m=4
XMDUM vss vss vss vss sg13_hv_nmos w=1u l=1u ng=1 m=12
XMB7 vss vbn2 vss vss sg13_hv_nmos w=2u l=4u ng=1 m=4
.ends

* expanding   symbol:  bg_res.sym # of pins=11
** sym_path: /home/tim/gits/sg13cmos5l_ocd_ip__biasgen/xschem/bg_res.sym
** sch_path: /home/tim/gits/sg13cmos5l_ocd_ip__biasgen/xschem/bg_res.sch
.subckt bg_res b a d c vss f h k e g j
*.PININFO a:I b:I c:O d:O vss:B f:O e:I h:O g:I k:O j:I
XR1 a net1 vss rhigh w=0.69u l=20u m=1 b=0
XR2 b net2 vss rhigh w=0.69u l=20u m=1 b=0
XR3 net1 net6 vss rhigh w=0.69u l=20u m=1 b=0
XR4 net2 net5 vss rhigh w=0.69u l=20u m=1 b=0
XR5 net6 net3 vss rhigh w=0.69u l=20u m=1 b=0
XR6 net5 net4 vss rhigh w=0.69u l=20u m=1 b=0
XR7 net3 net10 vss rhigh w=0.69u l=20u m=1 b=0
XR8 net4 net9 vss rhigh w=0.69u l=20u m=1 b=0
XR9 net10 net7 vss rhigh w=0.69u l=20u m=1 b=0
XR10 net9 net8 vss rhigh w=0.69u l=20u m=1 b=0
XR11 net7 net12 vss rhigh w=0.69u l=20u m=1 b=0
XR12 net8 net11 vss rhigh w=0.69u l=20u m=1 b=0
XR13 net12 net14 vss rhigh w=0.69u l=20u m=1 b=0
XR14 net11 net13 vss rhigh w=0.69u l=20u m=1 b=0
XR15 net14 net16 vss rhigh w=0.69u l=20u m=1 b=0
XR16 net13 net15 vss rhigh w=0.69u l=20u m=1 b=0
XR17 net16 net18 vss rhigh w=0.69u l=20u m=1 b=0
XR18 net15 net17 vss rhigh w=0.69u l=20u m=1 b=0
XR19 net18 c vss rhigh w=0.69u l=20u m=1 b=0
XR20 net17 d vss rhigh w=0.69u l=20u m=1 b=0
XR21 e f vss rhigh w=0.69u l=20u m=1 b=0
XR22 g h vss rhigh w=0.69u l=20u m=1 b=0
XR23 j k vss rhigh w=0.69u l=20u m=1 b=0
.ends

* expanding   symbol:  bg_trim.sym # of pins=4
** sym_path: /home/tim/gits/sg13cmos5l_ocd_ip__biasgen/xschem/bg_trim.sym
** sch_path: /home/tim/gits/sg13cmos5l_ocd_ip__biasgen/xschem/bg_trim.sch
.subckt bg_trim top bot ctl[15] ctl[14] ctl[13] ctl[12] ctl[11] ctl[10] ctl[9] ctl[8] ctl[7] ctl[6] ctl[5] ctl[4] ctl[3] ctl[2]
+ ctl[1] ctl[0] vss
*.PININFO vss:B ctl[15:0]:I bot:B top:B
XM0 net1 ctl[0] bot vss sg13_hv_nmos w=2u l=0.5u ng=1 m=1
XM1 net2 ctl[1] bot vss sg13_hv_nmos w=2u l=0.5u ng=1 m=1
XM2 net3 ctl[2] bot vss sg13_hv_nmos w=2u l=0.5u ng=1 m=1
XM3 net4 ctl[3] bot vss sg13_hv_nmos w=2u l=0.5u ng=1 m=1
XM4 net5 ctl[4] bot vss sg13_hv_nmos w=2u l=0.5u ng=1 m=1
XM5 net6 ctl[5] bot vss sg13_hv_nmos w=2u l=0.5u ng=1 m=1
XM6 net7 ctl[6] bot vss sg13_hv_nmos w=2u l=0.5u ng=1 m=1
XM7 net8 ctl[7] bot vss sg13_hv_nmos w=2u l=0.5u ng=1 m=1
XM12 net9 ctl[12] bot vss sg13_hv_nmos w=2u l=0.5u ng=1 m=1
XM13 net11 ctl[13] bot vss sg13_hv_nmos w=2u l=0.5u ng=1 m=1
XM14 net12 ctl[14] bot vss sg13_hv_nmos w=2u l=0.5u ng=1 m=1
XM15 top ctl[15] bot vss sg13_hv_nmos w=2u l=0.5u ng=1 m=1
XM8 net13 ctl[8] bot vss sg13_hv_nmos w=2u l=0.5u ng=1 m=1
XM9 net14 ctl[9] bot vss sg13_hv_nmos w=2u l=0.5u ng=1 m=1
XM10 net15 ctl[10] bot vss sg13_hv_nmos w=2u l=0.5u ng=1 m=1
XM11 net10 ctl[11] bot vss sg13_hv_nmos w=2u l=0.5u ng=1 m=1
XR15 top net12 vss rhigh w=1.41u l=3.4u m=1 b=0
XR1 net2 net1 vss rhigh w=1.41u l=3.4u m=1 b=0
XR16 net1 bot vss rhigh w=1.41u l=3.4u m=1 b=0
XR2 net3 net2 vss rhigh w=1.41u l=3.4u m=1 b=0
XR3 net4 net3 vss rhigh w=1.41u l=3.4u m=1 b=0
XR4 net5 net4 vss rhigh w=1.41u l=3.4u m=1 b=0
XR5 net6 net5 vss rhigh w=1.41u l=3.4u m=1 b=0
XR6 net7 net6 vss rhigh w=1.41u l=3.4u m=1 b=0
XR7 net8 net7 vss rhigh w=1.41u l=3.4u m=1 b=0
XR8 net13 net8 vss rhigh w=1.41u l=3.4u m=1 b=0
XR9 net14 net13 vss rhigh w=1.41u l=3.4u m=1 b=0
XR10 net15 net14 vss rhigh w=1.41u l=3.4u m=1 b=0
XR11 net10 net15 vss rhigh w=1.41u l=3.4u m=1 b=0
XR12 net9 net10 vss rhigh w=1.41u l=3.4u m=1 b=0
XR13 net11 net9 vss rhigh w=1.41u l=3.4u m=1 b=0
XR14 net12 net11 vss rhigh w=1.41u l=3.4u m=1 b=0
XM16 vss vss vss vss sg13_hv_nmos w=2u l=0.5u ng=1 m=2
XR17 vss vss vss rhigh w=1.41u l=3.4u m=1 b=0
XR18 top top vss rhigh w=1.41u l=3.4u m=1 b=0
.ends

* expanding   symbol:  se_folded_cascode_p.sym # of pins=7
** sym_path: /home/tim/gits/sg13cmos5l_ocd_ip__biasgen/xschem/se_folded_cascode_p.sym
** sch_path: /home/tim/gits/sg13cmos5l_ocd_ip__biasgen/xschem/se_folded_cascode_p.sch
.subckt se_folded_cascode_p vdd out inp inn vss bias ena_b
*.PININFO inn:I inp:I out:O bias:B vdd:B vss:B ena_b:I
XM3 out1p inn diff vdd sg13_hv_pmos w=4u l=1u ng=1 m=8
XM2 out1n inp diff vdd sg13_hv_pmos w=4u l=1u ng=1 m=8
XM1 diff vbp1 vdd vdd sg13_hv_pmos w=1u l=1u ng=1 m=16
XM4 out1n vbn1 vss vss sg13_hv_nmos w=1u l=1u ng=1 m=16
XM5 out1p vbn1 vss vss sg13_hv_nmos w=1u l=1u ng=1 m=16
XM6 mirr vbn2 out1n vss sg13_hv_nmos w=1u l=4u ng=1 m=8
XM7 out vbn2 out1p vss sg13_hv_nmos w=1u l=4u ng=1 m=8
XM8 mirr vbp2 nd10 vdd sg13_hv_pmos w=2u l=4u ng=1 m=8
XM9 out vbp2 nd11 vdd sg13_hv_pmos w=2u l=4u ng=1 m=8
XM10 nd10 mirr vdd vdd sg13_hv_pmos w=2u l=4u ng=1 m=8
XM11 nd11 mirr vdd vdd sg13_hv_pmos w=2u l=4u ng=1 m=8
XMB1 vbp2 vbp2 vbp1 vdd sg13_hv_pmos w=2u l=4u ng=1 m=4
XMB2 vbp1 vbp1 vdd vdd sg13_hv_pmos w=1u l=1u ng=1 m=4
XMB3 vbn2 vbp1 vdd vdd sg13_hv_pmos w=1u l=1u ng=1 m=4
XMB4 vbn2 vbn2 vbn1 vss sg13_hv_nmos w=1u l=4u ng=1 m=4
XMB5 vbn1 vbn1 vss vss sg13_hv_nmos w=1u l=1u ng=1 m=4
XMB6 bias ena_b vbp2 vdd sg13_hv_pmos w=2u l=4u ng=1 m=4
XM12 vdd vdd vdd vdd sg13_hv_pmos w=4u l=1u ng=1 m=8
XM13 vdd vdd vdd vdd sg13_hv_pmos w=1u l=1u ng=1 m=2
XMB7 vss vss vss vss sg13_hv_nmos w=1u l=1u ng=1 m=16
.ends

* expanding   symbol:  level_shift.sym # of pins=3
** sym_path: /home/tim/gits/sg13cmos5l_ocd_ip__biasgen/xschem/level_shift.sym
** sch_path: /home/tim/gits/sg13cmos5l_ocd_ip__biasgen/xschem/level_shift.sch
.subckt level_shift in_n in_p out vdd vss
*.PININFO in_n:I in_p:I out:O
XM1 net1 in_p vss vss sg13_hv_nmos w=4u l=0.5u ng=1 m=2
XM2 net1 S1_N vdd vdd sg13_hv_pmos w=1u l=0.5u ng=1 m=2
XM3 S1_N in_n vss vss sg13_hv_nmos w=4u l=0.5u ng=1 m=2
XM4 S1_N net1 vdd vdd sg13_hv_pmos w=1u l=0.5u ng=1 m=2
XM5 S2_N S1_N vdd vdd sg13_hv_pmos w=2u l=0.5u ng=1 m=2
XM6 S2_N S1_N vss vss sg13_hv_nmos w=1u l=0.5u ng=1 m=2
XM7 out S2_N vdd vdd sg13_hv_pmos w=2u l=0.5u ng=1 m=4
XM8 out S2_N vss vss sg13_hv_nmos w=1u l=0.5u ng=1 m=4
.ends
