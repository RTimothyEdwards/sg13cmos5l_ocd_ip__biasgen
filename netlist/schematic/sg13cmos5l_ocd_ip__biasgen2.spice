** sch_path: /home/tim/gits/sg13cmos5l_ocd_chipalooza/dependencies/sg13cmos5l_ocd_ip__biasgen/xschem/sg13cmos5l_ocd_ip__biasgen2.sch
.subckt sg13cmos5l_ocd_ip__biasgen2 ena avdd avss ref_in dvdd vbg ref_sel_vbg dvss bandgap_sink2[1] bandgap_sink2[0]
+ voltgen_source[4] voltgen_source[3] voltgen_source[2] voltgen_source[1] voltgen_source[0] bandgap_sink2_ibias voltgen_sink1[2] voltgen_sink1[1]
+ voltgen_sink1[0] voltgen_source_ibias idac1_source[4] idac1_source[3] idac1_source[2] idac1_source[1] idac1_source[0] voltgen_sink1_ibias
+ idac1_source_ibias idac2_source_ibias idac2_source[4] idac2_source[3] idac2_source[2] idac2_source[1] idac2_source[0] ref_sel_coarse ref_sel_fine
+ bandgap_sink1[2] bandgap_sink1[1] bandgap_sink1[0] bandgap_sink1_ibias voltgen_sink2[2] voltgen_sink2[1] voltgen_sink2[0] voltgen_sink2_ibias
*.PININFO avdd:B avss:B dvdd:B dvss:B ena:I ref_in:I vbg:I ref_sel_vbg:I bandgap_sink1[2:0]:I voltgen_sink1[2:0]:I
*+ voltgen_sink2[2:0]:I bandgap_sink1_ibias:B voltgen_sink1_ibias:B voltgen_sink2_ibias:B ref_sel_fine:I ref_sel_coarse:I voltgen_source_ibias:B
*+ voltgen_source[4:0]:I bandgap_sink2[1:0]:I bandgap_sink2_ibias:B idac1_source_ibias:B idac1_source[4:0]:I idac2_source_ibias:B idac2_source[4:0]:I
x1 avdd ena vbg net1 avss dvdd dvss ref_sel_vbg ref_in dvss nbias pcasc pbias net2 dvss ncasc ref_sel_fine ref_sel_coarse avdd
+ bias_generator_fe_v2
* noconn #net1
* noconn #net2
x13 dvdd dvss avdd pcasc pbias voltgen_source[4] voltgen_source[3] voltgen_source[2] voltgen_source[1] voltgen_source[0]
+ voltgen_source_ibias avss avdd avdd bias_generator_be0p_v2
x8[4] net4 avss ncasc nbias avss avss avss bias_nstack
x8[3] net4 avss ncasc nbias avss avss avss bias_nstack
x8[2] net4 avss ncasc nbias avss avss avss bias_nstack
x8[1] net4 avss ncasc nbias avss avss avss bias_nstack
x8[0] net4 avss ncasc nbias avss avss avss bias_nstack
x9[4] avdd pbias pcasc avdd net3 avdd avdd bias_pstack
x9[3] avdd pbias pcasc avdd net3 avdd avdd bias_pstack
x9[2] avdd pbias pcasc avdd net3 avdd avdd bias_pstack
x9[1] avdd pbias pcasc avdd net3 avdd avdd bias_pstack
x9[0] avdd pbias pcasc avdd net3 avdd avdd bias_pstack
* noconn #net4
* noconn #net3
x8 dvdd dvss avdd nbias avss bandgap_sink1[2] bandgap_sink1[1] bandgap_sink1[0] bandgap_sink1_ibias ncasc avss avss
+ bias_generator_ben1um
x3 dvdd dvss avdd nbias avss voltgen_sink1[2] voltgen_sink1[1] voltgen_sink1[0] voltgen_sink1_ibias ncasc avss avss
+ bias_generator_ben1um
x4 dvdd dvss avdd nbias avss voltgen_sink2[2] voltgen_sink2[1] voltgen_sink2[0] voltgen_sink2_ibias ncasc avss avss
+ bias_generator_ben1um
x2 dvdd dvss avdd nbias avss bandgap_sink2[1] bandgap_sink2[0] bandgap_sink2_ibias ncasc avss avss bias_generator_ben250nm
x5 dvdd dvss avdd pcasc pbias idac1_source[4] idac1_source[3] idac1_source[2] idac1_source[1] idac1_source[0] idac1_source_ibias
+ avss avdd avdd bias_generator_be0p_v2
x6 dvdd dvss avdd pcasc pbias idac2_source[4] idac2_source[3] idac2_source[2] idac2_source[1] idac2_source[0] idac2_source_ibias
+ avss avdd avdd bias_generator_be0p_v2
.ends

* expanding   symbol:  bias_generator_fe_v2.sym # of pins=19
** sym_path: /home/tim/gits/sg13cmos5l_ocd_chipalooza/dependencies/sg13cmos5l_ocd_ip__biasgen/xschem/bias_generator_fe_v2.sym
** sch_path: /home/tim/gits/sg13cmos5l_ocd_chipalooza/dependencies/sg13cmos5l_ocd_ip__biasgen/xschem/bias_generator_fe_v2.sch
.subckt bias_generator_fe_v2 avdd ena vbg src_test0 avss dvdd ena_src_test0 ref_sel_vbg ref_in dvss nbias pcasc pbias snk_test0
+ ena_snk_test0 ncasc ref_sel_fine ref_sel_coarse shld2
*.PININFO ref_in:I avss:B ref_sel_vbg:I avdd:B ena_src_test0:I ena_snk_test0:I src_test0:B snk_test0:B vbg:I ena:I dvdd:B dvss:B
*+ pcasc:O pbias:O nbias:O ncasc:O ref_sel_fine:I ref_sel_coarse:I shld2:B
XR4 ref_in net7 avss rhigh w=0.5u l=138.57u m=1 b=0
x4 net1 ena_3v3 ncasc nbias avss avss avss bias_nstack
x13[1] avdd pbias pcasc enb_test0_3v3 src_test0 shld2 avdd bias_pstack
x13[0] avdd pbias pcasc enb_test0_3v3 src_test0 shld2 avdd bias_pstack
x17[1] snk_test0 ena_test0_3v3 ncasc nbias avss avss avss bias_nstack
x17[0] snk_test0 ena_test0_3v3 ncasc nbias avss avss avss bias_nstack
x1 ref_sel_vbg net2 enb_vbg_3v3 avdd avss level_shift
x11 net5 ena_snk_test0 ena_test0_3v3 avdd avss level_shift
x23 ena_src_test0 net4 enb_test0_3v3 avdd avss level_shift
x24 net3 ena dvdd dvss sg13cmos5l_inv_2
x35 net2 ref_sel_vbg dvdd dvss sg13cmos5l_inv_2
XR1 net10 avss avss rhigh w=0.5u l=337.14u m=1 b=0
x36 net3 ena ena_3v3 avdd avss level_shift
Vmeas vfb net10 0
.save i(vmeas)
x19[2] avdd pbias pcasc enb_std_3v3 vfb shld2 avdd bias_pstack
x19[1] avdd pbias pcasc enb_std_3v3 vfb shld2 avdd bias_pstack
x19[0] avdd pbias pcasc enb_std_3v3 vfb shld2 avdd bias_pstack
x5[6] dvdd dvss sg13cmos5l_decap_4
x5[5] dvdd dvss sg13cmos5l_decap_4
x5[4] dvdd dvss sg13cmos5l_decap_4
x5[3] dvdd dvss sg13cmos5l_decap_4
x5[2] dvdd dvss sg13cmos5l_decap_4
x5[1] dvdd dvss sg13cmos5l_decap_4
x5[0] dvdd dvss sg13cmos5l_decap_4
x5 ref_sel_vbg dvdd dvss sg13cmos5l_antennanp
x6 ena dvdd dvss sg13cmos5l_antennanp
x7 ena_src_test0 dvdd dvss sg13cmos5l_antennanp
x8 ena_snk_test0 dvdd dvss sg13cmos5l_antennanp
C2 pbias vfb 228f m=1
x9 net4 ena_src_test0 dvdd dvss sg13cmos5l_inv_2
x10 net5 ena_snk_test0 dvdd dvss sg13cmos5l_inv_2
x12 net2 ref_sel_vbg ena_vbg_3v3 avdd avss level_shift
x1[15] nset ena_3v3 ncasc nbias avss avss avss bias_nset
x1[14] nset ena_3v3 ncasc nbias avss avss avss bias_nset
x1[13] nset ena_3v3 ncasc nbias avss avss avss bias_nset
x1[12] nset ena_3v3 ncasc nbias avss avss avss bias_nset
x1[11] nset ena_3v3 ncasc nbias avss avss avss bias_nset
x1[10] nset ena_3v3 ncasc nbias avss avss avss bias_nset
x1[9] nset ena_3v3 ncasc nbias avss avss avss bias_nset
x1[8] nset ena_3v3 ncasc nbias avss avss avss bias_nset
x1[7] nset ena_3v3 ncasc nbias avss avss avss bias_nset
x1[6] nset ena_3v3 ncasc nbias avss avss avss bias_nset
x1[5] nset ena_3v3 ncasc nbias avss avss avss bias_nset
x1[4] nset ena_3v3 ncasc nbias avss avss avss bias_nset
x1[3] nset ena_3v3 ncasc nbias avss avss avss bias_nset
x1[2] nset ena_3v3 ncasc nbias avss avss avss bias_nset
x1[1] nset ena_3v3 ncasc nbias avss avss avss bias_nset
x1[0] nset ena_3v3 ncasc nbias avss avss avss bias_nset
x14 avdd pbias pcasc ena_vbg_3v3 net6 avdd bias_pset
Vmeas1 net7 nset 0
.save i(vmeas1)
Vmeas2 net6 net1 0
.save i(vmeas2)
x3 avdd pbias vbg vfb nbias avss ena_vbg_3v3 bias_amp_large
x2[15] avdd pbias pcasc enb_fine_3v3 vfb shld2 avdd bias_pstack
x2[14] avdd pbias pcasc enb_fine_3v3 vfb shld2 avdd bias_pstack
x2[13] avdd pbias pcasc enb_fine_3v3 vfb shld2 avdd bias_pstack
x2[12] avdd pbias pcasc enb_fine_3v3 vfb shld2 avdd bias_pstack
x2[11] avdd pbias pcasc enb_fine_3v3 vfb shld2 avdd bias_pstack
x2[10] avdd pbias pcasc enb_fine_3v3 vfb shld2 avdd bias_pstack
x2[9] avdd pbias pcasc enb_fine_3v3 vfb shld2 avdd bias_pstack
x2[8] avdd pbias pcasc enb_fine_3v3 vfb shld2 avdd bias_pstack
x2[7] avdd pbias pcasc enb_fine_3v3 vfb shld2 avdd bias_pstack
x2[6] avdd pbias pcasc enb_fine_3v3 vfb shld2 avdd bias_pstack
x2[5] avdd pbias pcasc enb_fine_3v3 vfb shld2 avdd bias_pstack
x2[4] avdd pbias pcasc enb_fine_3v3 vfb shld2 avdd bias_pstack
x2[3] avdd pbias pcasc enb_fine_3v3 vfb shld2 avdd bias_pstack
x2[2] avdd pbias pcasc enb_fine_3v3 vfb shld2 avdd bias_pstack
x2[1] avdd pbias pcasc enb_fine_3v3 vfb shld2 avdd bias_pstack
x2[0] avdd pbias pcasc enb_fine_3v3 vfb shld2 avdd bias_pstack
x15 net9 net8 enb_fine_3v3 avdd avss level_shift
x16 net9 net8 dvdd dvss sg13cmos5l_inv_2
x17 net15 ref_sel_coarse ref_sel_fine dvdd dvss sg13cmos5l_nand2_1
x13 avdd pbias pcasc enb_coarse_3v3 vfb shld2 avdd bias_pstack
x18 net16 ref_sel_coarse net18 dvdd dvss sg13cmos5l_nor2_1
x19 net12 net11 enb_coarse_3v3 avdd avss level_shift
x20 net12 net11 dvdd dvss sg13cmos5l_inv_2
x21 net14 net13 enb_std_3v3 avdd avss level_shift
x22 net14 net13 dvdd dvss sg13cmos5l_inv_2
x25 net11 net15 ref_sel_vbg dvdd dvss sg13cmos5l_nand2_1
x26 net8 net16 ref_sel_vbg dvdd dvss sg13cmos5l_nand2_1
x27 net13 net17 ref_sel_vbg dvdd dvss sg13cmos5l_nand2_1
x29 net18 ref_sel_fine dvdd dvss sg13cmos5l_inv_2
x28 net17 net18 ref_sel_coarse dvdd dvss sg13cmos5l_nand2_1
x30 avdd dummypbias pcasc enb_vbg_3v3 net6 pbias avdd bias_pset2
x2 ref_sel_coarse dvdd dvss sg13cmos5l_antennanp
x31 ref_sel_fine dvdd dvss sg13cmos5l_antennanp
x4[1] avdd dummypbias pcasc avdd vfb pbias avdd bias_pstack
x4[0] avdd dummypbias pcasc avdd vfb pbias avdd bias_pstack
x3[1] nset avss ncasc nbias avss avss avss bias_nstack
x3[0] nset avss ncasc nbias avss avss avss bias_nstack
.ends

* expanding   symbol:  bias_generator_be0p_v2.sym # of pins=10
** sym_path: /home/tim/gits/sg13cmos5l_ocd_chipalooza/dependencies/sg13cmos5l_ocd_ip__biasgen/xschem/bias_generator_be0p_v2.sym
** sch_path: /home/tim/gits/sg13cmos5l_ocd_chipalooza/dependencies/sg13cmos5l_ocd_ip__biasgen/xschem/bias_generator_be0p_v2.sch
.subckt bias_generator_be0p_v2 dvdd dvss avdd pcasc pbias source_ena[4] source_ena[3] source_ena[2] source_ena[1] source_ena[0]
+ source_ibias avss shld2 shld3
*.PININFO avss:B avdd:B dvdd:B dvss:B pcasc:I pbias:I source_ena[4:0]:I source_ibias:B shld2:B shld3:B
x9[4] source_ena[4] net1[4] source_ena_b_3v3[4] avdd avss level_shift
x9[3] source_ena[3] net1[3] source_ena_b_3v3[3] avdd avss level_shift
x9[2] source_ena[2] net1[2] source_ena_b_3v3[2] avdd avss level_shift
x9[1] source_ena[1] net1[1] source_ena_b_3v3[1] avdd avss level_shift
x9[0] source_ena[0] net1[0] source_ena_b_3v3[0] avdd avss level_shift
x46[4] net1[4] source_ena[4] dvdd dvss sg13cmos5l_inv_2
x46[3] net1[3] source_ena[3] dvdd dvss sg13cmos5l_inv_2
x46[2] net1[2] source_ena[2] dvdd dvss sg13cmos5l_inv_2
x46[1] net1[1] source_ena[1] dvdd dvss sg13cmos5l_inv_2
x46[0] net1[0] source_ena[0] dvdd dvss sg13cmos5l_inv_2
x23[4] dvdd dvss sg13cmos5l_decap_4
x23[3] dvdd dvss sg13cmos5l_decap_4
x23[2] dvdd dvss sg13cmos5l_decap_4
x23[1] dvdd dvss sg13cmos5l_decap_4
x23[0] dvdd dvss sg13cmos5l_decap_4
x78[4] source_ena[4] dvdd dvss sg13cmos5l_antennanp
x78[3] source_ena[3] dvdd dvss sg13cmos5l_antennanp
x78[2] source_ena[2] dvdd dvss sg13cmos5l_antennanp
x78[1] source_ena[1] dvdd dvss sg13cmos5l_antennanp
x78[0] source_ena[0] dvdd dvss sg13cmos5l_antennanp
x9 avdd pbias pcasc source_ena_b_3v3[0] source_ibias shld2 shld3 bias_pstack
x10[1] avdd pbias pcasc source_ena_b_3v3[1] source_ibias shld2 shld3 bias_pstack
x10[0] avdd pbias pcasc source_ena_b_3v3[1] source_ibias shld2 shld3 bias_pstack
x1[3] avdd pbias pcasc source_ena_b_3v3[2] source_ibias shld2 shld3 bias_pstack
x1[2] avdd pbias pcasc source_ena_b_3v3[2] source_ibias shld2 shld3 bias_pstack
x1[1] avdd pbias pcasc source_ena_b_3v3[2] source_ibias shld2 shld3 bias_pstack
x1[0] avdd pbias pcasc source_ena_b_3v3[2] source_ibias shld2 shld3 bias_pstack
x2[7] avdd pbias pcasc source_ena_b_3v3[3] source_ibias shld2 shld3 bias_pstack
x2[6] avdd pbias pcasc source_ena_b_3v3[3] source_ibias shld2 shld3 bias_pstack
x2[5] avdd pbias pcasc source_ena_b_3v3[3] source_ibias shld2 shld3 bias_pstack
x2[4] avdd pbias pcasc source_ena_b_3v3[3] source_ibias shld2 shld3 bias_pstack
x2[3] avdd pbias pcasc source_ena_b_3v3[3] source_ibias shld2 shld3 bias_pstack
x2[2] avdd pbias pcasc source_ena_b_3v3[3] source_ibias shld2 shld3 bias_pstack
x2[1] avdd pbias pcasc source_ena_b_3v3[3] source_ibias shld2 shld3 bias_pstack
x2[0] avdd pbias pcasc source_ena_b_3v3[3] source_ibias shld2 shld3 bias_pstack
x3[15] avdd pbias pcasc source_ena_b_3v3[4] source_ibias shld2 shld3 bias_pstack
x3[14] avdd pbias pcasc source_ena_b_3v3[4] source_ibias shld2 shld3 bias_pstack
x3[13] avdd pbias pcasc source_ena_b_3v3[4] source_ibias shld2 shld3 bias_pstack
x3[12] avdd pbias pcasc source_ena_b_3v3[4] source_ibias shld2 shld3 bias_pstack
x3[11] avdd pbias pcasc source_ena_b_3v3[4] source_ibias shld2 shld3 bias_pstack
x3[10] avdd pbias pcasc source_ena_b_3v3[4] source_ibias shld2 shld3 bias_pstack
x3[9] avdd pbias pcasc source_ena_b_3v3[4] source_ibias shld2 shld3 bias_pstack
x3[8] avdd pbias pcasc source_ena_b_3v3[4] source_ibias shld2 shld3 bias_pstack
x3[7] avdd pbias pcasc source_ena_b_3v3[4] source_ibias shld2 shld3 bias_pstack
x3[6] avdd pbias pcasc source_ena_b_3v3[4] source_ibias shld2 shld3 bias_pstack
x3[5] avdd pbias pcasc source_ena_b_3v3[4] source_ibias shld2 shld3 bias_pstack
x3[4] avdd pbias pcasc source_ena_b_3v3[4] source_ibias shld2 shld3 bias_pstack
x3[3] avdd pbias pcasc source_ena_b_3v3[4] source_ibias shld2 shld3 bias_pstack
x3[2] avdd pbias pcasc source_ena_b_3v3[4] source_ibias shld2 shld3 bias_pstack
x3[1] avdd pbias pcasc source_ena_b_3v3[4] source_ibias shld2 shld3 bias_pstack
x3[0] avdd pbias pcasc source_ena_b_3v3[4] source_ibias shld2 shld3 bias_pstack
.ends

* expanding   symbol:  bias_nstack.sym # of pins=7
** sym_path: /home/tim/gits/sg13cmos5l_ocd_chipalooza/dependencies/sg13cmos5l_ocd_ip__biasgen/xschem/bias_nstack.sym
** sch_path: /home/tim/gits/sg13cmos5l_ocd_chipalooza/dependencies/sg13cmos5l_ocd_ip__biasgen/xschem/bias_nstack.sch
.subckt bias_nstack itail ena ncasc nbias avss shld2 shld3
*.PININFO avss:B ena:I nbias:I itail:B ncasc:I shld2:B shld3:B
XM3 net1 nbias avss avss sg13_hv_nmos w=3u l=1u ng=1 m=1
XM6 net2 ncasc net1 avss sg13_hv_nmos w=3u l=1u ng=1 m=1
XM12 itail ena net2 avss sg13_hv_nmos w=3u l=1u ng=1 m=1
.ends

* expanding   symbol:  bias_pstack.sym # of pins=7
** sym_path: /home/tim/gits/sg13cmos5l_ocd_chipalooza/dependencies/sg13cmos5l_ocd_ip__biasgen/xschem/bias_pstack.sym
** sch_path: /home/tim/gits/sg13cmos5l_ocd_chipalooza/dependencies/sg13cmos5l_ocd_ip__biasgen/xschem/bias_pstack.sch
.subckt bias_pstack avdd pbias pcasc enb itail shld2 shld3
*.PININFO avdd:B itail:B enb:I pcasc:I pbias:I shld2:B shld3:B
XM13 net1 pbias avdd avdd sg13_hv_pmos w=3u l=1u ng=1 m=1
XM18 itail enb net2 avdd sg13_hv_pmos w=3u l=1u ng=1 m=1
XM14 net2 pcasc net1 avdd sg13_hv_pmos w=3u l=1u ng=1 m=1
.ends

* expanding   symbol:  bias_generator_ben1um.sym # of pins=10
** sym_path: /home/tim/gits/sg13cmos5l_ocd_chipalooza/dependencies/sg13cmos5l_ocd_ip__biasgen/xschem/bias_generator_ben1um.sym
** sch_path: /home/tim/gits/sg13cmos5l_ocd_chipalooza/dependencies/sg13cmos5l_ocd_ip__biasgen/xschem/bias_generator_ben1um.sch
.subckt bias_generator_ben1um dvdd dvss avdd nbias avss sink_ena[2] sink_ena[1] sink_ena[0] sink_ibias ncasc shld2 shld3
*.PININFO avss:B avdd:B dvdd:B dvss:B nbias:I ncasc:I sink_ibias:B sink_ena[2:0]:I shld2:B shld3:B
x7[2] dvdd dvss sg13cmos5l_decap_4
x7[1] dvdd dvss sg13cmos5l_decap_4
x7[0] dvdd dvss sg13cmos5l_decap_4
x6[2] sink_ena[2] dvdd dvss sg13cmos5l_antennanp
x6[1] sink_ena[1] dvdd dvss sg13cmos5l_antennanp
x6[0] sink_ena[0] dvdd dvss sg13cmos5l_antennanp
x1[2] sink_ibias sink_ena_3v3[0] ncasc nbias avss shld2 shld3 bias_nstack
x1[1] sink_ibias sink_ena_3v3[0] ncasc nbias avss shld2 shld3 bias_nstack
x1[0] sink_ibias sink_ena_3v3[0] ncasc nbias avss shld2 shld3 bias_nstack
x2 sink_ibias sink_ena_3v3[1] ncasc nbias avss shld2 shld3 bias_nstack
x3 sink_ibias sink_ena_3v3[2] ncasc nbias avss shld2 shld3 bias_nstack
x4[2] net1[2] sink_ena[2] sink_ena_3v3[2] avdd avss level_shift
x4[1] net1[1] sink_ena[1] sink_ena_3v3[1] avdd avss level_shift
x4[0] net1[0] sink_ena[0] sink_ena_3v3[0] avdd avss level_shift
x5[2] net1[2] sink_ena[2] dvdd dvss sg13cmos5l_inv_2
x5[1] net1[1] sink_ena[1] dvdd dvss sg13cmos5l_inv_2
x5[0] net1[0] sink_ena[0] dvdd dvss sg13cmos5l_inv_2
x2[9] dummy_ibias avss ncasc nbias avss shld2 shld3 bias_nstack
x2[8] dummy_ibias avss ncasc nbias avss shld2 shld3 bias_nstack
x2[7] dummy_ibias avss ncasc nbias avss shld2 shld3 bias_nstack
x2[6] dummy_ibias avss ncasc nbias avss shld2 shld3 bias_nstack
x2[5] dummy_ibias avss ncasc nbias avss shld2 shld3 bias_nstack
x2[4] dummy_ibias avss ncasc nbias avss shld2 shld3 bias_nstack
x2[3] dummy_ibias avss ncasc nbias avss shld2 shld3 bias_nstack
x2[2] dummy_ibias avss ncasc nbias avss shld2 shld3 bias_nstack
x2[1] dummy_ibias avss ncasc nbias avss shld2 shld3 bias_nstack
x2[0] dummy_ibias avss ncasc nbias avss shld2 shld3 bias_nstack
.ends

* expanding   symbol:  bias_generator_ben250nm.sym # of pins=10
** sym_path: /home/tim/gits/sg13cmos5l_ocd_chipalooza/dependencies/sg13cmos5l_ocd_ip__biasgen/xschem/bias_generator_ben250nm.sym
** sch_path: /home/tim/gits/sg13cmos5l_ocd_chipalooza/dependencies/sg13cmos5l_ocd_ip__biasgen/xschem/bias_generator_ben250nm.sch
.subckt bias_generator_ben250nm dvdd dvss avdd nbias avss sink_ena[1] sink_ena[0] sink_ibias ncasc shld2 shld3
*.PININFO avss:B avdd:B dvdd:B dvss:B nbias:I ncasc:I sink_ibias:B sink_ena[1:0]:I shld2:B shld3:B
x7[1] dvdd dvss sg13cmos5l_decap_4
x7[0] dvdd dvss sg13cmos5l_decap_4
x6[1] sink_ena[1] dvdd dvss sg13cmos5l_antennanp
x6[0] sink_ena[0] dvdd dvss sg13cmos5l_antennanp
x2 sink_ibias sink_ena_3v3[1] ncasc nbias avss shld2 shld3 bias_nstack
x3 sink_ibias sink_ena_3v3[0] ncasc nbias avss shld2 shld3 bias_nstack
x4[1] net1[1] sink_ena[1] sink_ena_3v3[1] avdd avss level_shift
x4[0] net1[0] sink_ena[0] sink_ena_3v3[0] avdd avss level_shift
x5[1] net1[1] sink_ena[1] dvdd dvss sg13cmos5l_inv_2
x5[0] net1[0] sink_ena[0] dvdd dvss sg13cmos5l_inv_2
x1[7] dummy_bias avss ncasc nbias avss shld2 shld3 bias_nstack
x1[6] dummy_bias avss ncasc nbias avss shld2 shld3 bias_nstack
x1[5] dummy_bias avss ncasc nbias avss shld2 shld3 bias_nstack
x1[4] dummy_bias avss ncasc nbias avss shld2 shld3 bias_nstack
x1[3] dummy_bias avss ncasc nbias avss shld2 shld3 bias_nstack
x1[2] dummy_bias avss ncasc nbias avss shld2 shld3 bias_nstack
x1[1] dummy_bias avss ncasc nbias avss shld2 shld3 bias_nstack
x1[0] dummy_bias avss ncasc nbias avss shld2 shld3 bias_nstack
.ends

* expanding   symbol:  level_shift.sym # of pins=3
** sym_path: /home/tim/gits/sg13cmos5l_ocd_chipalooza/dependencies/sg13cmos5l_ocd_ip__biasgen/xschem/level_shift.sym
** sch_path: /home/tim/gits/sg13cmos5l_ocd_chipalooza/dependencies/sg13cmos5l_ocd_ip__biasgen/xschem/level_shift.sch
.subckt level_shift in_n in_p out vdd vss
*.PININFO in_n:I in_p:I out:O
XM1 net1 in_p vss vss sg13_hv_nmos w=4u l=0.5u ng=1 m=2
XM2 net1 S1_N vdd vdd sg13_hv_pmos w=1u l=0.5u ng=1 m=2
XM3 S1_N in_n vss vss sg13_hv_nmos w=4u l=0.5u ng=1 m=2
XM4 S1_N net1 vdd vdd sg13_hv_pmos w=1u l=0.5u ng=1 m=2
XM5 S2_N S1_N vdd vdd sg13_hv_pmos w=2u l=0.5u ng=1 m=2
XM6 S2_N S1_N vss vss sg13_hv_nmos w=1u l=0.5u ng=1 m=2
XM7 out S2_N vdd vdd sg13_hv_pmos w=2u l=0.5u ng=1 m=4
XM8 out S2_N vss vss sg13_hv_nmos w=1u l=0.5u ng=1 m=4
.ends

* expanding   symbol:  bias_nset.sym # of pins=7
** sym_path: /home/tim/gits/sg13cmos5l_ocd_chipalooza/dependencies/sg13cmos5l_ocd_ip__biasgen/xschem/bias_nset.sym
** sch_path: /home/tim/gits/sg13cmos5l_ocd_chipalooza/dependencies/sg13cmos5l_ocd_ip__biasgen/xschem/bias_nset.sch
.subckt bias_nset itail ena ncasc nbias avss shld2 shld3
*.PININFO avss:B ena:I itail:B nbias:O ncasc:O shld2:B shld3:B
XM3 nbias nbias avss avss sg13_hv_nmos w=3u l=1u ng=1 m=1
XM6 ncasc ncasc nbias avss sg13_hv_nmos w=3u l=1u ng=1 m=1
XM12 itail ena ncasc avss sg13_hv_nmos w=3u l=1u ng=1 m=1
.ends

* expanding   symbol:  bias_pset.sym # of pins=6
** sym_path: /home/tim/gits/sg13cmos5l_ocd_chipalooza/dependencies/sg13cmos5l_ocd_ip__biasgen/xschem/bias_pset.sym
** sch_path: /home/tim/gits/sg13cmos5l_ocd_chipalooza/dependencies/sg13cmos5l_ocd_ip__biasgen/xschem/bias_pset.sch
.subckt bias_pset avdd pbias pcasc enb itail shld3
*.PININFO pbias:B itail:B enb:I pcasc:O avdd:B shld3:B
XM13 pbias pbias avdd avdd sg13_hv_pmos w=3u l=1u ng=1 m=1
XM18 itail enb pcasc avdd sg13_hv_pmos w=3u l=1u ng=1 m=1
XM14 pcasc pcasc pbias avdd sg13_hv_pmos w=3u l=1u ng=1 m=1
.ends

* expanding   symbol:  bias_amp_large.sym # of pins=7
** sym_path: /home/tim/gits/sg13cmos5l_ocd_chipalooza/dependencies/sg13cmos5l_ocd_ip__biasgen/xschem/bias_amp_large.sym
** sch_path: /home/tim/gits/sg13cmos5l_ocd_chipalooza/dependencies/sg13cmos5l_ocd_ip__biasgen/xschem/bias_amp_large.sch
.subckt bias_amp_large avdd out inn inp nbias avss ena
*.PININFO inp:I nbias:I inn:I out:O avdd:B avss:B ena:I
XM1 net1 nbias avss avss sg13_hv_nmos w=20u l=1u ng=20 m=1
XM2 out outn avdd avdd sg13_hv_pmos w=10u l=0.5u ng=10 m=1
XM3 outn outn avdd avdd sg13_hv_pmos w=10u l=0.5u ng=10 m=1
XM4 outn inp vcom avss sg13_hv_nmos w=20u l=0.5u ng=20 m=1
XM5 out inn vcom avss sg13_hv_nmos w=20u l=0.5u ng=20 m=1
XM6 vcom ena net1 avss sg13_hv_nmos w=20u l=0.5u ng=20 m=1
XM7 avdd avdd avdd avdd sg13_hv_pmos w=2u l=0.5u ng=2 m=2
.ends

* expanding   symbol:  bias_pset2.sym # of pins=7
** sym_path: /home/tim/gits/sg13cmos5l_ocd_chipalooza/dependencies/sg13cmos5l_ocd_ip__biasgen/xschem/bias_pset2.sym
** sch_path: /home/tim/gits/sg13cmos5l_ocd_chipalooza/dependencies/sg13cmos5l_ocd_ip__biasgen/xschem/bias_pset2.sch
.subckt bias_pset2 avdd pbias pcasc enb itail shld2 shld3
*.PININFO pbias:B itail:B enb:I pcasc:O avdd:B shld2:B shld3:B
XM13 pbias pbias avdd avdd sg13_hv_pmos w=3u l=1u ng=1 m=1
XM18 itail enb pcasc avdd sg13_hv_pmos w=3u l=1u ng=1 m=1
XM14 pcasc pcasc pbias avdd sg13_hv_pmos w=3u l=1u ng=1 m=1
.ends
