* NGSPICE file created from sg13cmos5l_ocd_ip__bandgap_v3.ext - technology: ihp-sg13cmos5l

.subckt sg13cmos5l_ocd_ip__bandgap_v3 vdd vbg vss ibias1_250n trim[15] trim[14] trim[13]
+ trim[12] trim[11] trim[10] trim[9] trim[8] trim[7] trim[6] trim[5] trim[4] trim[3]
+ trim[2] trim[1] trim[0] dvss dvdd ena ibias2_1u
X0 x2.outb1n.t25 x2.vbn1 vss.t120 vss.t407 sg13_hv_nmos ad=0.34p pd=2.68u as=0.34p ps=2.68u w=1u l=1u
X1 x2.diffb x2.vbp1 vdd.t252 vdd.t5 sg13_hv_pmos ad=0.34p pd=2.68u as=0.34p ps=2.68u w=1u l=1u
X2 x1.xamp.vbn1 x1.xamp.vbn1 vss.t59 vss.t60 sg13_hv_nmos ad=0.34p pd=2.68u as=0.34p ps=2.68u w=1u l=1u
X3 x2.diffb vbg.t17 x2.outb1n.t22 vdd.t5 sg13_hv_pmos ad=1.36p pd=8.68u as=1.36p ps=8.68u w=4u l=1u
X4 x1.xtr.XM0[1].S x1.XQ2_7.E vss.t0 rppd l=3.4u w=1.41u
X5 vss.t59 vss.t59 vss.t234 rhigh l=20u w=0.69u
X6 vss.t271 x1.level_shift_0[5].in_n x1.level_shift_0[5].XM7.G0 vss.t172 sg13_hv_nmos ad=0.76p pd=4.38u as=1.36p ps=8.68u w=4u l=0.5u
X7 x2.XM9.D0_0 x2.XM9.D0_0 x2.outa1n.t33 vdd.t5 sg13_hv_pmos ad=0.34p pd=2.68u as=0.34p ps=2.68u w=1u l=4u
X8 x1.XM1.G0 x1.xamp.vbp2 x1.xamp.XM8.D0 vdd.t6 sg13_hv_pmos ad=0.68p pd=4.68u as=0.68p ps=4.68u w=2u l=4u
X9 vss.t59 vss.t59 vss.t59 vss.t75 sg13_hv_nmos ad=0.34p pd=2.68u as=0 ps=0 w=1u l=1u
X10 x2.diffb x1.vbg x2.outb1p.t6 vdd.t5 sg13_hv_pmos ad=1.36p pd=8.68u as=1.36p ps=8.68u w=4u l=1u
X11 x2.diffa vbg.t10 x2.outa1n.t45 vss.t99 sg13_hv_nmos ad=0.68p pd=4.68u as=0.68p ps=4.68u w=2u l=1u
X12 x1.xtr.XM0[3].S x1.xtr.XM0[2].S vss.t0 rppd l=3.4u w=1.41u
X13 x1.xamp.vbn1 x1.xamp.vbn1 vss.t59 vss.t60 sg13_hv_nmos ad=0.34p pd=2.68u as=0.34p ps=2.68u w=1u l=1u
X14 x1.xamp.XM1.S0 x1.xamp.vbp1 vdd.t6 vdd.t6 sg13_hv_pmos ad=0.34p pd=2.68u as=0.34p ps=2.68u w=1u l=1u
X15 vss.t177 x1.x1[2].in_n x1.x1[2].XM7.G0 vss.t236 sg13_hv_nmos ad=0.76p pd=4.38u as=1.36p ps=8.68u w=4u l=0.5u
X16 x1.xamp.XM1.S0 x1.xamp.vbp1 vdd.t6 vdd.t6 sg13_hv_pmos ad=0.34p pd=2.68u as=0.34p ps=2.68u w=1u l=1u
X17 x1.xtr.XM0[4].S x1.xtr.XM0[3].S vss.t0 rppd l=3.4u w=1.41u
X18 vdd.t146 x1.level_shift_0[0].XM7.D0 x1.level_shift_0[0].out vdd.t0 sg13_hv_pmos ad=0.68p pd=4.68u as=0.38p ps=2.38u w=2u l=0.5u
X19 vdd.t31 x1.xamp.XM6.S0 x1.xamp.XM8.D0 vdd.t6 sg13_hv_pmos ad=0.68p pd=4.68u as=0.68p ps=4.68u w=2u l=4u
X20 vss.t380 x1.x1[0].in_p x1.x1[0].XM2.D0 vss.t381 sg13_hv_nmos ad=0.76p pd=4.38u as=1.36p ps=8.68u w=4u l=0.5u
X21 x1.x1[2].out x1.x1[2].XM7.D0 vss.t177 vss.t176 sg13_hv_nmos ad=0.19p pd=1.38u as=0.34p ps=2.68u w=1u l=0.5u
X22 x2.vbn2 x2.vbn2 x2.vbn1 vss.t306 sg13_hv_nmos ad=0.68p pd=4.68u as=0.68p ps=4.68u w=2u l=4u
X23 vdd.t57 x1.x1[0].XM7.D0 x1.ena_b_h vdd.t0 sg13_hv_pmos ad=0.68p pd=4.68u as=0.38p ps=2.38u w=2u l=0.5u
X24 x1.level_shift_0[0].XM7.G0 x1.level_shift_0[0].XM2.D0 vdd.t198 vdd.t0 sg13_hv_pmos ad=0.34p pd=2.68u as=0.19p ps=1.38u w=1u l=0.5u
X25 vdd.t111 x1.level_shift_0[6].XM7.G0 x1.level_shift_0[6].XM7.D0 vdd.t0 sg13_hv_pmos ad=0.38p pd=2.38u as=0.68p ps=4.68u w=2u l=0.5u
X26 x1.xtr.XM0[7].S x1.xtr.XM0[6].S vss.t0 rppd l=3.4u w=1.41u
X27 x1.xamp.out1n x1.xres.d x1.xamp.XM1.S0 vdd.t6 sg13_hv_pmos ad=1.36p pd=8.68u as=1.36p ps=8.68u w=4u l=1u
X28 x2.outb1p.t30 x2.vbn1 vss.t95 vss.t414 sg13_hv_nmos ad=0.34p pd=2.68u as=0.34p ps=2.68u w=1u l=1u
X29 x2.diffa x1.vbg x2.outa1p.t2 vss.t24 sg13_hv_nmos ad=0.68p pd=4.68u as=0.68p ps=4.68u w=2u l=1u
X30 x1.x1[5].out x1.x1[5].XM7.D0 vdd.t159 vdd.t0 sg13_hv_pmos ad=0.38p pd=2.38u as=0.38p ps=2.38u w=2u l=0.5u
X31 x2.outb1n.t30 x2.vbn1 vss.t95 vss.t415 sg13_hv_nmos ad=0.34p pd=2.68u as=0.34p ps=2.68u w=1u l=1u
X32 x2.XMB4.S0 x1.ena_b_h ibias2_1u vdd.t5 sg13_hv_pmos ad=0.34p pd=2.68u as=0.34p ps=2.68u w=1u l=4u
X33 vdd.t93 x1.level_shift_0[3].XM7.D0 x1.level_shift_0[3].out vdd.t0 sg13_hv_pmos ad=0.68p pd=4.68u as=0.38p ps=2.38u w=2u l=0.5u
X34 x2.diffa vbg.t13 x2.outa1n.t42 vss.t350 sg13_hv_nmos ad=0.68p pd=4.68u as=0.68p ps=4.68u w=2u l=1u
X35 x2.outa1p.t34 x2.outa1n.t50 vdd.t5 vdd.t5 sg13_hv_pmos ad=0.34p pd=2.68u as=0.34p ps=2.68u w=1u l=1u
X36 vdd.t288 x1.x1[7].XM7.D0 x1.x1[7].out vdd.t0 sg13_hv_pmos ad=0.68p pd=4.68u as=0.38p ps=2.38u w=2u l=0.5u
X37 vdd.t157 x1.x1[7].XM7.G0 x1.x1[7].XM2.D0 vdd.t0 sg13_hv_pmos ad=0.19p pd=1.38u as=0.34p ps=2.68u w=1u l=0.5u
X38 x1.XM1.G0 x1.xamp.vbn2 x1.xamp.out1p vss.t181 sg13_hv_nmos ad=0.34p pd=2.68u as=0.34p ps=2.68u w=1u l=4u
X39 x1.xamp.out1p x1.xamp.vbn1 vss.t59 vss.t65 sg13_hv_nmos ad=0.34p pd=2.68u as=0.34p ps=2.68u w=1u l=1u
X40 x1.xamp.out1n x1.xamp.vbn1 vss.t59 vss.t77 sg13_hv_nmos ad=0.34p pd=2.68u as=0.34p ps=2.68u w=1u l=1u
X41 vss.t135 x1.x1[0].XM7.D0 x1.ena_b_h vss.t134 sg13_hv_nmos ad=0.34p pd=2.68u as=0.19p ps=1.38u w=1u l=0.5u
X42 vdd.t50 vdd.t50 vdd.t50 vdd.t6 sg13_hv_pmos ad=1.36p pd=8.68u as=0 ps=0 w=4u l=1u
X43 vss.t14 x1.level_shift_0[0].XM7.D0 x1.level_shift_0[0].out vss.t221 sg13_hv_nmos ad=0.34p pd=2.68u as=0.19p ps=1.38u w=1u l=0.5u
X44 x1.xres.XR1[6].R1 x1.xres.XR1[4].R2 vss.t9 rhigh l=20u w=0.69u
X45 vdd.t21 x1.xamp.XM6.S0 x1.xamp.XM8.S1 vdd.t6 sg13_hv_pmos ad=0.68p pd=4.68u as=0.68p ps=4.68u w=2u l=4u
X46 vss.t14 x1.level_shift_0[0].XM7.G0 x1.level_shift_0[0].XM7.D0 vss.t221 sg13_hv_nmos ad=0.34p pd=2.68u as=0.19p ps=1.38u w=1u l=0.5u
X47 x1.level_shift_0[3].XM7.G0 x1.level_shift_0[3].XM2.D0 vdd.t15 vdd.t0 sg13_hv_pmos ad=0.34p pd=2.68u as=0.19p ps=1.38u w=1u l=0.5u
X48 x2.diffb x2.vbp1 vdd.t252 vdd.t5 sg13_hv_pmos ad=0.34p pd=2.68u as=0.34p ps=2.68u w=1u l=1u
X49 x1.x1[3].out x1.x1[3].XM7.D0 vdd.t181 vdd.t0 sg13_hv_pmos ad=0.38p pd=2.38u as=0.38p ps=2.38u w=2u l=0.5u
X50 vss.t7 x1.x1[2].XM7.G0 x1.x1[2].XM7.D0 vss.t174 sg13_hv_nmos ad=0.34p pd=2.68u as=0.19p ps=1.38u w=1u l=0.5u
X51 x1.x1[1].XM7.G0 x1.x1[1].in_n vss.t242 vss.t269 sg13_hv_nmos ad=1.36p pd=8.68u as=0.76p ps=4.38u w=4u l=0.5u
X52 x1.xamp.out1n x1.xamp.vbn1 vss.t59 vss.t65 sg13_hv_nmos ad=0.34p pd=2.68u as=0.34p ps=2.68u w=1u l=1u
X53 vdd.t88 x1.level_shift_0[7].XM7.G0 x1.level_shift_0[7].XM7.D0 vdd.t0 sg13_hv_pmos ad=0.38p pd=2.38u as=0.68p ps=4.68u w=2u l=0.5u
X54 x1.xamp.out1p x1.xamp.vbn1 vss.t59 vss.t77 sg13_hv_nmos ad=0.34p pd=2.68u as=0.34p ps=2.68u w=1u l=1u
X55 x1.xamp.out1n x1.xres.d x1.xamp.XM1.S0 vdd.t6 sg13_hv_pmos ad=1.36p pd=8.68u as=1.36p ps=8.68u w=4u l=1u
X56 x2.XMB4.S0 x1.ena_b_h ibias2_1u vdd.t5 sg13_hv_pmos ad=0.34p pd=2.68u as=0.34p ps=2.68u w=1u l=4u
X57 vdd.t199 x1.level_shift_0[0].XM7.G0 x1.level_shift_0[0].XM2.D0 vdd.t0 sg13_hv_pmos ad=0.19p pd=1.38u as=0.34p ps=2.68u w=1u l=0.5u
X58 vdd.t27 x1.xamp.XM6.S0 x1.xamp.XM8.D0 vdd.t6 sg13_hv_pmos ad=0.68p pd=4.68u as=0.68p ps=4.68u w=2u l=4u
X59 x1.x1[4].out x1.x1[4].XM7.D0 vdd.t113 vdd.t0 sg13_hv_pmos ad=0.38p pd=2.38u as=0.38p ps=2.38u w=2u l=0.5u
X60 x1.level_shift_0[2].XM7.G0 x1.level_shift_0[2].XM2.D0 vdd.t219 vdd.t0 sg13_hv_pmos ad=0.34p pd=2.68u as=0.19p ps=1.38u w=1u l=0.5u
X61 x1.xamp.XM6.S0 x1.xamp.vbn2 x1.xamp.out1n vss.t181 sg13_hv_nmos ad=0.34p pd=2.68u as=0.34p ps=2.68u w=1u l=4u
X62 x2.outb1n.t8 x2.vbn2 x2.XM9.D0_0 vss.t318 sg13_hv_nmos ad=0.68p pd=4.68u as=0.68p ps=4.68u w=2u l=4u
X63 vss.t95 vss.t95 vss.t95 vss.t103 sg13_hv_nmos ad=0.34p pd=2.68u as=0 ps=0 w=1u l=1u
X64 x1.xtr.XM0[5].S x1.xtr.XM0[4].S vss.t0 rppd l=3.4u w=1.41u
X65 x1.xamp.out1n x1.xamp.vbn1 vss.t59 vss.t65 sg13_hv_nmos ad=0.34p pd=2.68u as=0.34p ps=2.68u w=1u l=1u
X66 x1.xamp.out1p x1.xamp.vbn1 vss.t59 vss.t77 sg13_hv_nmos ad=0.34p pd=2.68u as=0.34p ps=2.68u w=1u l=1u
X67 x2.outb1p.t35 x2.vbn1 vss.t95 vss.t424 sg13_hv_nmos ad=0.34p pd=2.68u as=0.34p ps=2.68u w=1u l=1u
X68 x1.level_shift_0[5].out x1.level_shift_0[5].XM7.D0 vdd.t194 vdd.t0 sg13_hv_pmos ad=0.38p pd=2.38u as=0.38p ps=2.38u w=2u l=0.5u
X69 x1.x1[4].out x1.x1[4].XM7.D0 vss.t171 vss.t170 sg13_hv_nmos ad=0.19p pd=1.38u as=0.34p ps=2.68u w=1u l=0.5u
X70 vss.t95 vss.t95 vss.t95 vss.t105 sg13_hv_nmos ad=0.34p pd=2.68u as=0 ps=0 w=1u l=1u
X71 x2.outb1n.t35 x2.vbn1 vss.t95 vss.t425 sg13_hv_nmos ad=0.34p pd=2.68u as=0.34p ps=2.68u w=1u l=1u
X72 vdd.t60 x1.x1[0].XM7.G0 x1.x1[0].XM7.D0 vdd.t0 sg13_hv_pmos ad=0.38p pd=2.38u as=0.68p ps=4.68u w=2u l=0.5u
X73 vdd.t86 x1.level_shift_0[7].XM7.D0 x1.level_shift_0[7].out vdd.t0 sg13_hv_pmos ad=0.68p pd=4.68u as=0.38p ps=2.38u w=2u l=0.5u
X74 x1.x1[6].XM7.G0 x1.x1[6].XM2.D0 vdd.t89 vdd.t0 sg13_hv_pmos ad=0.34p pd=2.68u as=0.19p ps=1.38u w=1u l=0.5u
X75 x1.xres.XR1[14].R1 x1.xres.XR1[16].R2 vss.t130 rhigh l=20u w=0.69u
X76 vdd.t3 x1.level_shift_0[5].XM7.G0 x1.level_shift_0[5].XM2.D0 vdd.t0 sg13_hv_pmos ad=0.19p pd=1.38u as=0.34p ps=2.68u w=1u l=0.5u
X77 x1.xtr.XM0[8].S x1.xtr.XM0[7].S vss.t0 rppd l=3.4u w=1.41u
X78 vdd.t98 x1.level_shift_0[1].XM7.G0 x1.level_shift_0[1].XM2.D0 vdd.t0 sg13_hv_pmos ad=0.19p pd=1.38u as=0.34p ps=2.68u w=1u l=0.5u
X79 vss.t7 x1.x1[3].in_n x1.x1[3].XM7.G0 vss.t163 sg13_hv_nmos ad=0.76p pd=4.38u as=1.36p ps=8.68u w=4u l=0.5u
X80 vss.t120 vss.t111 vss.t119 vss.t118 sg13_hv_nmos ad=0.34p pd=2.68u as=0 ps=0 w=1u l=1u
X81 vss.t59 vss.t59 vss.t59 vss.t75 sg13_hv_nmos ad=0.34p pd=2.68u as=0 ps=0 w=1u l=1u
X82 x2.outa1p.t13 x2.outa1n.t52 vdd.t5 vdd.t5 sg13_hv_pmos ad=0.34p pd=2.68u as=0.34p ps=2.68u w=1u l=1u
X83 x2.XM9.D0_0 x2.XM9.D0_0 x2.outa1n.t35 vdd.t5 sg13_hv_pmos ad=0.34p pd=2.68u as=0.34p ps=2.68u w=1u l=4u
X84 x2.vbp1 x2.vbp1 vdd.t252 vdd.t5 sg13_hv_pmos ad=0.34p pd=2.68u as=0.34p ps=2.68u w=1u l=1u
X85 vss.t135 trim[15] x1.x1[1].XM2.D0 vss.t250 sg13_hv_nmos ad=0.76p pd=4.38u as=1.36p ps=8.68u w=4u l=0.5u
X86 vss.t59 vss.t59 vss.t59 vss.t60 sg13_hv_nmos ad=0.34p pd=2.68u as=0 ps=0 w=1u l=1u
X87 x1.level_shift_0[6].out x1.level_shift_0[6].XM7.D0 vdd.t111 vdd.t0 sg13_hv_pmos ad=0.38p pd=2.38u as=0.38p ps=2.38u w=2u l=0.5u
X88 x2.outa1n.t17 x2.outa1n.t16 vdd.t5 vdd.t5 sg13_hv_pmos ad=0.34p pd=2.68u as=0.34p ps=2.68u w=1u l=1u
X89 x1.x1[0].XM7.D0 x1.x1[0].XM7.G0 vss.t135 vss.t137 sg13_hv_nmos ad=0.19p pd=1.38u as=0.34p ps=2.68u w=1u l=0.5u
X90 x1.x1[5].out x1.x1[5].XM7.D0 vss.t11 vss.t248 sg13_hv_nmos ad=0.19p pd=1.38u as=0.34p ps=2.68u w=1u l=0.5u
X91 x1.level_shift_0[5].out x1.level_shift_0[5].XM7.D0 vss.t271 vss.t124 sg13_hv_nmos ad=0.19p pd=1.38u as=0.34p ps=2.68u w=1u l=0.5u
X92 x1.XM1.G0 x1.xamp.vbp2 x1.xamp.XM8.D0 vdd.t6 sg13_hv_pmos ad=0.68p pd=4.68u as=0.68p ps=4.68u w=2u l=4u
X93 x2.outa1n.t5 x2.outa1n.t4 vdd.t112 vdd.t5 sg13_hv_pmos ad=0.34p pd=2.68u as=0.34p ps=2.68u w=1u l=1u
X94 x1.xamp.XM1.S0 x1.xamp.vbp1 vdd.t6 vdd.t6 sg13_hv_pmos ad=0.34p pd=2.68u as=0.34p ps=2.68u w=1u l=1u
X95 x1.level_shift_0[5].XM7.D0 x1.level_shift_0[5].XM7.G0 vss.t271 vss.t131 sg13_hv_nmos ad=0.19p pd=1.38u as=0.34p ps=2.68u w=1u l=0.5u
X96 x2.outb1p.t18 x2.vbn2 x2.XMOP.G0_0 vss.t321 sg13_hv_nmos ad=0.68p pd=4.68u as=0.68p ps=4.68u w=2u l=4u
X97 x2.outa1p.t14 x2.outa1n.t57 vdd.t112 vdd.t5 sg13_hv_pmos ad=0.34p pd=2.68u as=0.34p ps=2.68u w=1u l=1u
X98 x1.x1[7].XM7.D0 x1.x1[7].XM7.G0 vss.t155 vss.t355 sg13_hv_nmos ad=0.19p pd=1.38u as=0.34p ps=2.68u w=1u l=0.5u
X99 x2.outb1n.t5 x2.vbn2 x2.XM9.D0_0 vss.t309 sg13_hv_nmos ad=0.68p pd=4.68u as=0.68p ps=4.68u w=2u l=4u
X100 x2.outb1p.t36 x2.vbn1 vss.t120 vss.t404 sg13_hv_nmos ad=0.34p pd=2.68u as=0.34p ps=2.68u w=1u l=1u
X101 x1.x1[8].XM7.G0 x1.x1[8].in_n vss.t18 vss.t17 sg13_hv_nmos ad=1.36p pd=8.68u as=0.76p ps=4.38u w=4u l=0.5u
X102 vss.t242 trim[13] x1.x1[2].XM2.D0 vss.t290 sg13_hv_nmos ad=0.76p pd=4.38u as=1.36p ps=8.68u w=4u l=0.5u
X103 vss.t31 x1.level_shift_0[2].XM7.D0 x1.level_shift_0[2].out vss.t342 sg13_hv_nmos ad=0.34p pd=2.68u as=0.19p ps=1.38u w=1u l=0.5u
X104 vdd.t12 x1.level_shift_0[7].XM7.G0 x1.level_shift_0[7].XM2.D0 vdd.t0 sg13_hv_pmos ad=0.19p pd=1.38u as=0.34p ps=2.68u w=1u l=0.5u
X105 x1.xamp.XM6.S0 x1.xamp.vbn2 x1.xamp.out1n vss.t180 sg13_hv_nmos ad=0.34p pd=2.68u as=0.34p ps=2.68u w=1u l=4u
X106 vdd.t133 x1.x1[2].XM7.G0 x1.x1[2].XM7.D0 vdd.t0 sg13_hv_pmos ad=0.38p pd=2.38u as=0.68p ps=4.68u w=2u l=0.5u
X107 vdd.t50 vdd.t50 vdd.t50 vdd.t6 sg13_hv_pmos ad=1.36p pd=8.68u as=0 ps=0 w=4u l=1u
X108 vss.t18 x1.x1[8].XM7.D0 x1.x1[8].out vss.t295 sg13_hv_nmos ad=0.34p pd=2.68u as=0.19p ps=1.38u w=1u l=0.5u
X109 x1.level_shift_0[4].XM7.G0 x1.level_shift_0[4].XM2.D0 vdd.t1 vdd.t0 sg13_hv_pmos ad=0.34p pd=2.68u as=0.19p ps=1.38u w=1u l=0.5u
X110 x1.x1[1].XM7.D0 x1.x1[1].XM7.G0 vss.t242 vss.t243 sg13_hv_nmos ad=0.19p pd=1.38u as=0.34p ps=2.68u w=1u l=0.5u
X111 x2.diffa x2.vbn1 vss.t95 vss.t107 sg13_hv_nmos ad=0.34p pd=2.68u as=0.34p ps=2.68u w=1u l=1u
X112 x2.outa1p.t24 x2.XM9.D0_0 x2.XMOP.G0_0 vdd.t5 sg13_hv_pmos ad=0.34p pd=2.68u as=0.34p ps=2.68u w=1u l=4u
X113 x1.xamp.XM6.S0 x1.xamp.vbp2 x1.xamp.XM8.S1 vdd.t6 sg13_hv_pmos ad=0.68p pd=4.68u as=0.68p ps=4.68u w=2u l=4u
X114 x1.level_shift_0[2].out x1.level_shift_0[2].XM7.D0 vdd.t232 vdd.t0 sg13_hv_pmos ad=0.38p pd=2.38u as=0.38p ps=2.38u w=2u l=0.5u
X115 x1.x1[2].XM7.G0 x1.x1[2].in_n vss.t177 vss.t235 sg13_hv_nmos ad=1.36p pd=8.68u as=0.76p ps=4.38u w=4u l=0.5u
X116 x2.outb1n.t7 x2.vbn2 x2.XM9.D0_0 vss.t313 sg13_hv_nmos ad=0.68p pd=4.68u as=0.68p ps=4.68u w=2u l=4u
X117 x1.xamp.out1p x1.xres.c x1.xamp.XM1.S0 vdd.t6 sg13_hv_pmos ad=1.36p pd=8.68u as=1.36p ps=8.68u w=4u l=1u
X118 vss.t259 x1.level_shift_0[1].in_n x1.level_shift_0[1].XM7.G0 vss.t377 sg13_hv_nmos ad=0.76p pd=4.38u as=1.36p ps=8.68u w=4u l=0.5u
X119 vdd.t16 x1.level_shift_0[3].XM7.G0 x1.level_shift_0[3].XM2.D0 vdd.t0 sg13_hv_pmos ad=0.19p pd=1.38u as=0.34p ps=2.68u w=1u l=0.5u
X120 vss.t7 x1.x1[2].XM7.D0 x1.x1[2].out vss.t174 sg13_hv_nmos ad=0.34p pd=2.68u as=0.19p ps=1.38u w=1u l=0.5u
X121 x1.x1[0].XM2.D0 x1.x1[0].in_p vss.t380 vss.t379 sg13_hv_nmos ad=1.36p pd=8.68u as=0.76p ps=4.38u w=4u l=0.5u
X122 vss.t11 x1.x1[5].in_n x1.x1[5].XM7.G0 vss.t232 sg13_hv_nmos ad=0.76p pd=4.38u as=1.36p ps=8.68u w=4u l=0.5u
X123 vdd.t94 x1.level_shift_0[3].XM7.D0 x1.level_shift_0[3].out vdd.t0 sg13_hv_pmos ad=0.68p pd=4.68u as=0.38p ps=2.38u w=2u l=0.5u
X124 vss.t125 x1.level_shift_0[4].XM7.D0 x1.level_shift_0[4].out vss.t124 sg13_hv_nmos ad=0.34p pd=2.68u as=0.19p ps=1.38u w=1u l=0.5u
X125 vdd.t131 x1.x1[2].XM7.D0 x1.x1[2].out vdd.t0 sg13_hv_pmos ad=0.68p pd=4.68u as=0.38p ps=2.38u w=2u l=0.5u
X126 vss.t125 x1.level_shift_0[4].XM7.G0 x1.level_shift_0[4].XM7.D0 vss.t131 sg13_hv_nmos ad=0.34p pd=2.68u as=0.19p ps=1.38u w=1u l=0.5u
X127 vss.t59 vss.t59 vss.t59 vss.t77 sg13_hv_nmos ad=0.34p pd=2.68u as=0 ps=0 w=1u l=1u
X128 x2.outb1n.t40 x2.vbn1 vss.t391 vss.t412 sg13_hv_nmos ad=0.34p pd=2.68u as=0.34p ps=2.68u w=1u l=1u
X129 x2.diffb x2.vbp1 vdd.t252 vdd.t5 sg13_hv_pmos ad=0.34p pd=2.68u as=0.34p ps=2.68u w=1u l=1u
X130 x2.outb1p.t14 x2.vbn2 x2.XMOP.G0_0 vss.t312 sg13_hv_nmos ad=0.68p pd=4.68u as=0.68p ps=4.68u w=2u l=4u
X131 x2.vbn1 x2.vbn1 vss.t111 vss.t400 sg13_hv_nmos ad=0.34p pd=2.68u as=0.34p ps=2.68u w=1u l=1u
X132 vss.t111 vss.t111 vss.t111 vss.t112 sg13_hv_nmos ad=0.34p pd=2.68u as=0 ps=0 w=1u l=1u
X133 x2.vbn1 x2.vbn1 vss.t115 vss.t401 sg13_hv_nmos ad=0.34p pd=2.68u as=0.34p ps=2.68u w=1u l=1u
X134 x2.outa1n.t13 x2.outa1n.t12 vdd.t5 vdd.t5 sg13_hv_pmos ad=0.34p pd=2.68u as=0.34p ps=2.68u w=1u l=1u
X135 x2.vbn2 x2.vbp1 vdd.t252 vdd.t5 sg13_hv_pmos ad=0.34p pd=2.68u as=0.34p ps=2.68u w=1u l=1u
X136 vdd.t23 x1.xamp.XM6.S0 x1.xamp.XM8.S1 vdd.t6 sg13_hv_pmos ad=0.68p pd=4.68u as=0.68p ps=4.68u w=2u l=4u
X137 x2.outa1p.t12 x2.outa1n.t53 vdd.t5 vdd.t5 sg13_hv_pmos ad=0.34p pd=2.68u as=0.34p ps=2.68u w=1u l=1u
X138 x1.level_shift_0[6].XM7.G0 x1.level_shift_0[6].XM2.D0 vdd.t171 vdd.t0 sg13_hv_pmos ad=0.34p pd=2.68u as=0.19p ps=1.38u w=1u l=0.5u
X139 x2.diffa vbg.t8 x2.outa1n.t47 vss.t353 sg13_hv_nmos ad=0.68p pd=4.68u as=0.68p ps=4.68u w=2u l=1u
X140 x1.xamp.vbn2 x1.xamp.vbp1 vdd.t6 vdd.t6 sg13_hv_pmos ad=0.34p pd=2.68u as=0.34p ps=2.68u w=1u l=1u
X141 x2.outa1p.t11 x2.outa1n.t59 vdd.t121 vdd.t5 sg13_hv_pmos ad=0.34p pd=2.68u as=0.34p ps=2.68u w=1u l=1u
X142 vss.t14 trim[14] x1.level_shift_0[0].XM2.D0 vss.t15 sg13_hv_nmos ad=0.76p pd=4.38u as=1.36p ps=8.68u w=4u l=0.5u
X143 x2.diffb x2.vbp1 vdd.t252 vdd.t5 sg13_hv_pmos ad=0.34p pd=2.68u as=0.34p ps=2.68u w=1u l=1u
X144 vdd.t179 x1.x1[3].XM7.D0 x1.x1[3].out vdd.t0 sg13_hv_pmos ad=0.68p pd=4.68u as=0.38p ps=2.38u w=2u l=0.5u
X145 x2.diffb x2.vbp1 vdd.t252 vdd.t5 sg13_hv_pmos ad=0.34p pd=2.68u as=0.34p ps=2.68u w=1u l=1u
X146 x1.x1[0].XM7.G0 x1.x1[0].XM2.D0 vdd.t152 vdd.t0 sg13_hv_pmos ad=0.34p pd=2.68u as=0.19p ps=1.38u w=1u l=0.5u
X147 vdd.t114 x1.x1[4].XM7.G0 x1.x1[4].XM7.D0 vdd.t0 sg13_hv_pmos ad=0.38p pd=2.38u as=0.68p ps=4.68u w=2u l=0.5u
X148 x1.xamp.XM1.S0 x1.xamp.vbp1 vdd.t50 vdd.t6 sg13_hv_pmos ad=0.34p pd=2.68u as=0.34p ps=2.68u w=1u l=1u
X149 vdd.t126 x1.x1[3].XM7.G0 x1.x1[3].XM2.D0 vdd.t0 sg13_hv_pmos ad=0.19p pd=1.38u as=0.34p ps=2.68u w=1u l=0.5u
X150 x1.xres.XR1[5].R1 x1.xres.XR1[3].R2 vss.t1 rhigh l=20u w=0.69u
X151 x1.level_shift_0[0].XM7.G0 x1.level_shift_0[0].in_n vss.t14 vss.t291 sg13_hv_nmos ad=1.36p pd=8.68u as=0.76p ps=4.38u w=4u l=0.5u
X152 x2.vbp1 x2.vbp1 vdd.t121 vdd.t5 sg13_hv_pmos ad=0.34p pd=2.68u as=0.34p ps=2.68u w=1u l=1u
X153 x1.ena_b_h x1.x1[0].XM7.D0 vss.t135 vss.t137 sg13_hv_nmos ad=0.19p pd=1.38u as=0.34p ps=2.68u w=1u l=0.5u
X154 x1.x1[4].XM7.G0 x1.x1[4].in_n vss.t171 vss.t293 sg13_hv_nmos ad=1.36p pd=8.68u as=0.76p ps=4.38u w=4u l=0.5u
X155 x2.diffa x2.vbn1 vss.t95 vss.t99 sg13_hv_nmos ad=0.34p pd=2.68u as=0.34p ps=2.68u w=1u l=1u
X156 vss.t14 trim[12] x1.level_shift_0[1].XM2.D0 vss.t268 sg13_hv_nmos ad=0.76p pd=4.38u as=1.36p ps=8.68u w=4u l=0.5u
X157 x1.x1[8].XM7.D0 x1.x1[8].XM7.G0 vss.t18 vss.t296 sg13_hv_nmos ad=0.19p pd=1.38u as=0.34p ps=2.68u w=1u l=0.5u
X158 vss.t155 x1.x1[7].in_n x1.x1[7].XM7.G0 vss.t375 sg13_hv_nmos ad=0.76p pd=4.38u as=1.36p ps=8.68u w=4u l=0.5u
X159 x1.level_shift_0[7].XM7.G0 x1.level_shift_0[7].XM2.D0 vdd.t12 vdd.t0 sg13_hv_pmos ad=0.34p pd=2.68u as=0.19p ps=1.38u w=1u l=0.5u
X160 x1.XQ2_7.E x1.level_shift_0[3].out x1.xtr.XM0[9].S vss.t56 sg13_hv_nmos ad=0.68p pd=4.68u as=0.68p ps=4.68u w=2u l=0.5u
X161 x1.level_shift_0[1].out x1.level_shift_0[1].XM7.D0 vss.t259 vss.t261 sg13_hv_nmos ad=0.19p pd=1.38u as=0.34p ps=2.68u w=1u l=0.5u
X162 vss.t11 x1.x1[4].XM7.D0 x1.x1[4].out vss.t169 sg13_hv_nmos ad=0.34p pd=2.68u as=0.19p ps=1.38u w=1u l=0.5u
X163 x1.x1[7].out x1.x1[7].XM7.D0 vss.t155 vss.t355 sg13_hv_nmos ad=0.19p pd=1.38u as=0.34p ps=2.68u w=1u l=0.5u
X164 x1.xamp.out1p x1.xres.c x1.xamp.XM1.S0 vdd.t6 sg13_hv_pmos ad=1.36p pd=8.68u as=1.36p ps=8.68u w=4u l=1u
X165 vss.t11 trim[7] x1.x1[5].XM2.D0 vss.t12 sg13_hv_nmos ad=0.76p pd=4.38u as=1.36p ps=8.68u w=4u l=0.5u
X166 x1.XM1.S0 x1.XM1.G0 vdd.t105 vdd.t101 sg13_hv_pmos ad=1.36p pd=8.68u as=1.36p ps=8.68u w=4u l=1u
X167 x2.outb1n.t12 x2.vbn2 x2.XM9.D0_0 vss.t317 sg13_hv_nmos ad=0.68p pd=4.68u as=0.68p ps=4.68u w=2u l=4u
X168 x2.outa1n.t23 x2.outa1n.t22 vdd.t5 vdd.t5 sg13_hv_pmos ad=0.34p pd=2.68u as=0.34p ps=2.68u w=1u l=1u
X169 x1.ena_b_h x1.x1[0].XM7.D0 vdd.t60 vdd.t0 sg13_hv_pmos ad=0.38p pd=2.38u as=0.38p ps=2.38u w=2u l=0.5u
X170 vdd.t174 x1.level_shift_0[1].XM7.G0 x1.level_shift_0[1].XM7.D0 vdd.t0 sg13_hv_pmos ad=0.38p pd=2.38u as=0.68p ps=4.68u w=2u l=0.5u
X171 vdd.t81 x2.XMOP.G0_0 vbg.t6 vdd.t5 sg13_hv_pmos ad=1.36p pd=8.68u as=1.36p ps=8.68u w=4u l=4u
X172 x2.outa1p.t20 x2.XM9.D0_0 x2.XMOP.G0_0 vdd.t5 sg13_hv_pmos ad=0.34p pd=2.68u as=0.34p ps=2.68u w=1u l=4u
X173 x2.diffb x1.vbg x2.outb1p.t5 vdd.t5 sg13_hv_pmos ad=1.36p pd=8.68u as=1.36p ps=8.68u w=4u l=1u
X174 vss.t155 x1.x1[6].XM7.G0 x1.x1[6].XM7.D0 vss.t154 sg13_hv_nmos ad=0.34p pd=2.68u as=0.19p ps=1.38u w=1u l=0.5u
X175 vss.t4 vdd.t292 x1.vs2 x1.vs2 sg13_hv_pmos ad=0.34p pd=2.68u as=0.34p ps=2.68u w=1u l=1u
X176 vdd.t19 x1.xamp.XM6.S0 x1.xamp.XM8.D0 vdd.t6 sg13_hv_pmos ad=0.68p pd=4.68u as=0.68p ps=4.68u w=2u l=4u
X177 x1.XQ2_7.E x1.x1[3].out x1.xtr.XM0[12].S vss.t56 sg13_hv_nmos ad=0.68p pd=4.68u as=0.68p ps=4.68u w=2u l=0.5u
X178 x2.outb1n.t1 x2.vbn2 x2.XM9.D0_0 vss.t300 sg13_hv_nmos ad=0.68p pd=4.68u as=0.68p ps=4.68u w=2u l=4u
X179 x2.outa1p.t35 x2.outa1n.t54 vdd.t5 vdd.t5 sg13_hv_pmos ad=0.34p pd=2.68u as=0.34p ps=2.68u w=1u l=1u
X180 x1.x1[1].out x1.x1[1].XM7.D0 vss.t242 vss.t243 sg13_hv_nmos ad=0.19p pd=1.38u as=0.34p ps=2.68u w=1u l=0.5u
X181 x1.XQ2_7.E x1.level_shift_0[1].out x1.xtr.XM0[13].S vss.t56 sg13_hv_nmos ad=0.68p pd=4.68u as=0.68p ps=4.68u w=2u l=0.5u
X182 vss.t276 x1.level_shift_0[2].in_n x1.level_shift_0[2].XM7.G0 vss.t277 sg13_hv_nmos ad=0.76p pd=4.38u as=1.36p ps=8.68u w=4u l=0.5u
X183 vdd.t2 x1.level_shift_0[4].XM7.G0 x1.level_shift_0[4].XM2.D0 vdd.t0 sg13_hv_pmos ad=0.19p pd=1.38u as=0.34p ps=2.68u w=1u l=0.5u
X184 vss.t299 x2.vbn2 vss.t298 vss.t315 sg13_hv_nmos ad=0.68p pd=4.68u as=0 ps=0 w=2u l=4u
X185 x1.XQ2_7.E x1.level_shift_0[0].out x1.xtr.XM0[15].S vss.t56 sg13_hv_nmos ad=0.68p pd=4.68u as=0.68p ps=4.68u w=2u l=0.5u
X186 vss.t47 vss.t46 x1.XQ2_7.E pnpMPA a=1.4p p=5.4u
**devattr d=249408261,157565
X187 vdd.t172 x1.level_shift_0[1].XM7.D0 x1.level_shift_0[1].out vdd.t0 sg13_hv_pmos ad=0.68p pd=4.68u as=0.38p ps=2.38u w=2u l=0.5u
X188 x1.XM1.G0 x1.xamp.vbn2 x1.xamp.out1p vss.t181 sg13_hv_nmos ad=0.34p pd=2.68u as=0.34p ps=2.68u w=1u l=4u
X189 x1.XM1.G0 x1.xamp.vbn2 x1.xamp.out1p vss.t180 sg13_hv_nmos ad=0.34p pd=2.68u as=0.34p ps=2.68u w=1u l=4u
X190 x2.outa1p.t26 x2.XM9.D0_0 x2.XMOP.G0_0 vdd.t5 sg13_hv_pmos ad=0.34p pd=2.68u as=0.34p ps=2.68u w=1u l=4u
X191 x1.x1[8].XM2.D0 trim[1] vss.t18 vss.t142 sg13_hv_nmos ad=1.36p pd=8.68u as=0.76p ps=4.38u w=4u l=0.5u
X192 vdd.t243 x1.x1[5].XM7.D0 x1.x1[5].out vdd.t0 sg13_hv_pmos ad=0.68p pd=4.68u as=0.38p ps=2.38u w=2u l=0.5u
X193 x1.xamp.out1n x1.xamp.vbn1 vss.t59 vss.t65 sg13_hv_nmos ad=0.34p pd=2.68u as=0.34p ps=2.68u w=1u l=1u
X194 x1.xamp.out1p x1.xamp.vbn1 vss.t59 vss.t77 sg13_hv_nmos ad=0.34p pd=2.68u as=0.34p ps=2.68u w=1u l=1u
X195 x2.diffa x1.vbg x2.outa1p.t1 vss.t23 sg13_hv_nmos ad=0.68p pd=4.68u as=0.68p ps=4.68u w=2u l=1u
X196 x2.XM9.D0_0 x2.XM9.D0_0 x2.outa1n.t24 vdd.t5 sg13_hv_pmos ad=0.34p pd=2.68u as=0.34p ps=2.68u w=1u l=4u
X197 x2.diffb vbg.t20 x2.outb1n.t19 vdd.t5 sg13_hv_pmos ad=1.36p pd=8.68u as=1.36p ps=8.68u w=4u l=1u
X198 x1.x1[8].out x1.x1[8].XM7.D0 vdd.t210 vdd.t0 sg13_hv_pmos ad=0.38p pd=2.38u as=0.38p ps=2.38u w=2u l=0.5u
X199 vss.t18 x1.x1[7].XM7.G0 x1.x1[7].XM7.D0 vss.t354 sg13_hv_nmos ad=0.34p pd=2.68u as=0.19p ps=1.38u w=1u l=0.5u
X200 x2.outb1p.t26 x2.vbn1 vss.t120 vss.t408 sg13_hv_nmos ad=0.34p pd=2.68u as=0.34p ps=2.68u w=1u l=1u
X201 x2.diffb x2.vbp1 vdd.t252 vdd.t5 sg13_hv_pmos ad=0.34p pd=2.68u as=0.34p ps=2.68u w=1u l=1u
X202 vdd.t32 x1.xamp.XM6.S0 x1.xamp.XM8.S1 vdd.t6 sg13_hv_pmos ad=0.68p pd=4.68u as=0.68p ps=4.68u w=2u l=4u
X203 x1.level_shift_0[2].out x1.level_shift_0[2].XM7.D0 vdd.t233 vdd.t0 sg13_hv_pmos ad=0.38p pd=2.38u as=0.38p ps=2.38u w=2u l=0.5u
X204 x2.outb1p.t12 x2.vbn2 x2.XMOP.G0_0 vss.t308 sg13_hv_nmos ad=0.68p pd=4.68u as=0.68p ps=4.68u w=2u l=4u
X205 x2.outb1n.t26 x2.vbn1 vss.t391 vss.t410 sg13_hv_nmos ad=0.34p pd=2.68u as=0.34p ps=2.68u w=1u l=1u
X206 vss.t59 vss.t59 vss.t59 vss.t77 sg13_hv_nmos ad=0.34p pd=2.68u as=0 ps=0 w=1u l=1u
X207 vss.t95 vss.t95 vss.t95 vss.t26 sg13_hv_nmos ad=0.34p pd=2.68u as=0 ps=0 w=1u l=1u
X208 x1.level_shift_0[7].XM7.G0 x1.level_shift_0[7].in_n vss.t58 vss.t172 sg13_hv_nmos ad=1.36p pd=8.68u as=0.76p ps=4.38u w=4u l=0.5u
X209 x1.level_shift_0[3].out x1.level_shift_0[3].XM7.D0 vss.t132 vss.t126 sg13_hv_nmos ad=0.19p pd=1.38u as=0.34p ps=2.68u w=1u l=0.5u
X210 x2.vbn2 x2.vbn2 x2.vbn1 vss.t297 sg13_hv_nmos ad=0.68p pd=4.68u as=0.68p ps=4.68u w=2u l=4u
X211 x1.x1[2].out x1.x1[2].XM7.D0 vdd.t132 vdd.t0 sg13_hv_pmos ad=0.38p pd=2.38u as=0.38p ps=2.38u w=2u l=0.5u
X212 vdd.t230 x1.level_shift_0[2].XM7.D0 x1.level_shift_0[2].out vdd.t0 sg13_hv_pmos ad=0.68p pd=4.68u as=0.38p ps=2.38u w=2u l=0.5u
X213 x2.diffb vbg.t23 x2.outb1n.t16 vdd.t5 sg13_hv_pmos ad=1.36p pd=8.68u as=1.36p ps=8.68u w=4u l=1u
X214 x1.x1[1].XM7.G0 x1.x1[1].XM2.D0 vdd.t107 vdd.t0 sg13_hv_pmos ad=0.34p pd=2.68u as=0.19p ps=1.38u w=1u l=0.5u
X215 vdd.t160 x1.x1[5].XM7.G0 x1.x1[5].XM7.D0 vdd.t0 sg13_hv_pmos ad=0.38p pd=2.38u as=0.68p ps=4.68u w=2u l=0.5u
X216 vdd.t13 x1.level_shift_0[3].XM7.G0 x1.level_shift_0[3].XM7.D0 vdd.t0 sg13_hv_pmos ad=0.38p pd=2.38u as=0.68p ps=4.68u w=2u l=0.5u
X217 x1.xamp.XM1.S0 x1.xamp.vbp1 vdd.t6 vdd.t6 sg13_hv_pmos ad=0.34p pd=2.68u as=0.34p ps=2.68u w=1u l=1u
X218 x1.level_shift_0[1].XM7.G0 x1.level_shift_0[1].in_n vss.t259 vss.t376 sg13_hv_nmos ad=1.36p pd=8.68u as=0.76p ps=4.38u w=4u l=0.5u
X219 x1.xamp.vbp1 x1.xamp.vbp1 vdd.t6 vdd.t6 sg13_hv_pmos ad=0.34p pd=2.68u as=0.34p ps=2.68u w=1u l=1u
X220 vdd.t22 x1.xamp.XM6.S0 x1.xamp.XM8.D0 vdd.t6 sg13_hv_pmos ad=0.68p pd=4.68u as=0.68p ps=4.68u w=2u l=4u
X221 x1.x1[5].XM7.G0 x1.x1[5].in_n vss.t11 vss.t231 sg13_hv_nmos ad=1.36p pd=8.68u as=0.76p ps=4.38u w=4u l=0.5u
X222 x2.XM9.D0_0 x2.XM9.D0_0 x2.outa1n.t37 vdd.t5 sg13_hv_pmos ad=0.34p pd=2.68u as=0.34p ps=2.68u w=1u l=4u
X223 x2.outb1p.t41 x2.vbn1 vss.t95 vss.t413 sg13_hv_nmos ad=0.34p pd=2.68u as=0.34p ps=2.68u w=1u l=1u
X224 x2.diffb vbg.t19 x2.outb1n.t20 vdd.t5 sg13_hv_pmos ad=1.36p pd=8.68u as=1.36p ps=8.68u w=4u l=1u
X225 vss.t125 x1.level_shift_0[4].in_n x1.level_shift_0[4].XM7.G0 vss.t172 sg13_hv_nmos ad=0.76p pd=4.38u as=1.36p ps=8.68u w=4u l=0.5u
X226 vss.t132 trim[6] x1.level_shift_0[4].XM2.D0 vss.t239 sg13_hv_nmos ad=0.76p pd=4.38u as=1.36p ps=8.68u w=4u l=0.5u
X227 x2.outb1p.t23 x2.vbn2 x2.XMOP.G0_0 vss.t324 sg13_hv_nmos ad=0.68p pd=4.68u as=0.68p ps=4.68u w=2u l=4u
X228 x1.XQ2_7.E x1.x1[2].out x1.xtr.XM0[14].S vss.t56 sg13_hv_nmos ad=0.68p pd=4.68u as=0.68p ps=4.68u w=2u l=0.5u
X229 vdd.t153 x1.x1[1].XM7.G0 x1.x1[1].XM7.D0 vdd.t0 sg13_hv_pmos ad=0.38p pd=2.38u as=0.68p ps=4.68u w=2u l=0.5u
X230 x1.level_shift_0[4].out x1.level_shift_0[4].XM7.D0 vss.t125 vss.t126 sg13_hv_nmos ad=0.19p pd=1.38u as=0.34p ps=2.68u w=1u l=0.5u
X231 x1.x1[8].out x1.x1[8].XM7.D0 vss.t18 vss.t296 sg13_hv_nmos ad=0.19p pd=1.38u as=0.34p ps=2.68u w=1u l=0.5u
X232 x2.outb1p.t31 x2.vbn1 vss.t95 vss.t416 sg13_hv_nmos ad=0.34p pd=2.68u as=0.34p ps=2.68u w=1u l=1u
X233 x1.xamp.XM1.S0 x1.xamp.vbp1 vdd.t50 vdd.t6 sg13_hv_pmos ad=0.34p pd=2.68u as=0.34p ps=2.68u w=1u l=1u
X234 x1.x1[4].XM7.G0 x1.x1[4].XM2.D0 vdd.t116 vdd.t0 sg13_hv_pmos ad=0.34p pd=2.68u as=0.19p ps=1.38u w=1u l=0.5u
X235 x2.outb1n.t6 x2.vbn2 x2.XM9.D0_0 vss.t311 sg13_hv_nmos ad=0.68p pd=4.68u as=0.68p ps=4.68u w=2u l=4u
X236 vss.t148 x2.XMOP.G0_0 vbg.t1 vss.t144 sg13_hv_nmos ad=1.36p pd=8.68u as=1.36p ps=8.68u w=4u l=4u
X237 x1.xamp.out1p x1.xres.c x1.xamp.XM1.S0 vdd.t6 sg13_hv_pmos ad=1.36p pd=8.68u as=1.36p ps=8.68u w=4u l=1u
X238 vdd.t28 x1.xamp.XM6.S0 x1.xamp.XM8.D0 vdd.t6 sg13_hv_pmos ad=0.68p pd=4.68u as=0.68p ps=4.68u w=2u l=4u
X239 x1.XQ2_7.E x1.x1[1].out x1.xtr.top vss.t56 sg13_hv_nmos ad=0.68p pd=4.68u as=0.68p ps=4.68u w=2u l=0.5u
X240 vss.t44 vss.t43 x1.XQ2_7.E pnpMPA a=1.4p p=5.4u
**devattr d=249408261,157565
X241 vss.t63 vss.t63 vss.t63 vss.t56 sg13_hv_nmos ad=0.68p pd=4.68u as=0 ps=0 w=2u l=0.5u
X242 x1.x1[3].out x1.x1[3].XM7.D0 vss.t7 vss.t265 sg13_hv_nmos ad=0.19p pd=1.38u as=0.34p ps=2.68u w=1u l=0.5u
X243 vss.t155 x1.x1[6].XM7.D0 x1.x1[6].out vss.t154 sg13_hv_nmos ad=0.34p pd=2.68u as=0.19p ps=1.38u w=1u l=0.5u
X244 vdd.t106 x1.x1[1].XM7.G0 x1.x1[1].XM2.D0 vdd.t0 sg13_hv_pmos ad=0.19p pd=1.38u as=0.34p ps=2.68u w=1u l=0.5u
X245 vdd.t220 x1.x1[1].XM7.D0 x1.x1[1].out vdd.t0 sg13_hv_pmos ad=0.68p pd=4.68u as=0.38p ps=2.38u w=2u l=0.5u
X246 x1.level_shift_0[1].XM7.G0 x1.level_shift_0[1].XM2.D0 vdd.t97 vdd.t0 sg13_hv_pmos ad=0.34p pd=2.68u as=0.19p ps=1.38u w=1u l=0.5u
X247 x1.level_shift_0[7].XM2.D0 trim[0] vss.t58 vss.t239 sg13_hv_nmos ad=1.36p pd=8.68u as=0.76p ps=4.38u w=4u l=0.5u
X248 x1.x1[3].XM7.G0 x1.x1[3].XM2.D0 vdd.t125 vdd.t0 sg13_hv_pmos ad=0.34p pd=2.68u as=0.19p ps=1.38u w=1u l=0.5u
X249 vss.t58 x1.level_shift_0[7].XM7.D0 x1.level_shift_0[7].out vss.t126 sg13_hv_nmos ad=0.34p pd=2.68u as=0.19p ps=1.38u w=1u l=0.5u
X250 x1.xres.XR1[18].R1 x1.xres.d vss.t341 rhigh l=20u w=0.69u
X251 x2.outb1n.t45 x2.vbn1 vss.t95 vss.t420 sg13_hv_nmos ad=0.34p pd=2.68u as=0.34p ps=2.68u w=1u l=1u
X252 vdd.t213 x1.x1[6].XM7.D0 x1.x1[6].out vdd.t0 sg13_hv_pmos ad=0.68p pd=4.68u as=0.38p ps=2.38u w=2u l=0.5u
X253 vdd.t7 x1.level_shift_0[4].XM7.D0 x1.level_shift_0[4].out vdd.t0 sg13_hv_pmos ad=0.68p pd=4.68u as=0.38p ps=2.38u w=2u l=0.5u
X254 vss.t59 vss.t59 vss.t59 vss.t60 sg13_hv_nmos ad=0.34p pd=2.68u as=0 ps=0 w=1u l=1u
X255 vdd.t235 x1.x1[7].XM7.G0 x1.x1[7].XM7.D0 vdd.t0 sg13_hv_pmos ad=0.38p pd=2.38u as=0.68p ps=4.68u w=2u l=0.5u
X256 vdd.t17 x1.xamp.XM6.S0 x1.xamp.XM8.S1 vdd.t6 sg13_hv_pmos ad=0.68p pd=4.68u as=0.68p ps=4.68u w=2u l=4u
X257 x1.level_shift_0[7].out x1.level_shift_0[7].XM7.D0 vdd.t87 vdd.t0 sg13_hv_pmos ad=0.38p pd=2.38u as=0.38p ps=2.38u w=2u l=0.5u
X258 vdd.t92 x1.x1[6].XM7.G0 x1.x1[6].XM2.D0 vdd.t0 sg13_hv_pmos ad=0.19p pd=1.38u as=0.34p ps=2.68u w=1u l=0.5u
X259 vdd.t175 x1.level_shift_0[1].XM7.G0 x1.level_shift_0[1].XM7.D0 vdd.t0 sg13_hv_pmos ad=0.38p pd=2.38u as=0.68p ps=4.68u w=2u l=0.5u
X260 x1.level_shift_0[3].XM7.G0 x1.level_shift_0[3].in_n vss.t132 vss.t172 sg13_hv_nmos ad=1.36p pd=8.68u as=0.76p ps=4.38u w=4u l=0.5u
X261 vss.t259 x1.level_shift_0[1].XM7.D0 x1.level_shift_0[1].out vss.t258 sg13_hv_nmos ad=0.34p pd=2.68u as=0.19p ps=1.38u w=1u l=0.5u
X262 vss.t259 x1.level_shift_0[1].XM7.G0 x1.level_shift_0[1].XM7.D0 vss.t258 sg13_hv_nmos ad=0.34p pd=2.68u as=0.19p ps=1.38u w=1u l=0.5u
X263 vss.t18 x1.x1[7].XM7.D0 x1.x1[7].out vss.t354 sg13_hv_nmos ad=0.34p pd=2.68u as=0.19p ps=1.38u w=1u l=0.5u
X264 vss.t167 x1.level_shift_0[6].in_n x1.level_shift_0[6].XM7.G0 vss.t172 sg13_hv_nmos ad=0.76p pd=4.38u as=1.36p ps=8.68u w=4u l=0.5u
X265 x1.xtr.XM0[6].S x1.xtr.XM0[5].S vss.t0 rppd l=3.4u w=1.41u
X266 x1.xres.XR1[2].R1 x1.xres.XR1[4].R2 vss.t129 rhigh l=20u w=0.69u
X267 x1.xamp.out1p x1.xamp.vbn1 vss.t59 vss.t65 sg13_hv_nmos ad=0.34p pd=2.68u as=0.34p ps=2.68u w=1u l=1u
X268 x1.xamp.out1n x1.xamp.vbn1 vss.t59 vss.t77 sg13_hv_nmos ad=0.34p pd=2.68u as=0.34p ps=2.68u w=1u l=1u
X269 vdd.t137 x1.x1[2].XM7.G0 x1.x1[2].XM2.D0 vdd.t0 sg13_hv_pmos ad=0.19p pd=1.38u as=0.34p ps=2.68u w=1u l=0.5u
X270 x2.outb1p.t39 x2.vbn1 vss.t391 vss.t411 sg13_hv_nmos ad=0.34p pd=2.68u as=0.34p ps=2.68u w=1u l=1u
X271 x1.xamp.vbn1 x1.xamp.vbn2 x1.xamp.vbn2 vss.t180 sg13_hv_nmos ad=0.34p pd=2.68u as=0.34p ps=2.68u w=1u l=4u
X272 vdd.t83 x2.XMOP.G0_0 vbg.t2 vdd.t5 sg13_hv_pmos ad=1.36p pd=8.68u as=1.36p ps=8.68u w=4u l=4u
X273 x2.vbp1 x2.XMB4.S0 x2.XMB4.S0 vdd.t5 sg13_hv_pmos ad=0.34p pd=2.68u as=0.34p ps=2.68u w=1u l=4u
X274 x1.xtr.XM0[9].S x1.xtr.XM0[8].S vss.t0 rppd l=3.4u w=1.41u
X275 vdd.t173 x1.level_shift_0[1].XM7.D0 x1.level_shift_0[1].out vdd.t0 sg13_hv_pmos ad=0.68p pd=4.68u as=0.38p ps=2.38u w=2u l=0.5u
X276 vdd.t9 x1.level_shift_0[4].XM7.G0 x1.level_shift_0[4].XM7.D0 vdd.t0 sg13_hv_pmos ad=0.38p pd=2.38u as=0.68p ps=4.68u w=2u l=0.5u
X277 x1.xamp.XM1.S0 x1.xamp.vbp1 vdd.t50 vdd.t6 sg13_hv_pmos ad=0.34p pd=2.68u as=0.34p ps=2.68u w=1u l=1u
X278 vdd.t209 x1.x1[8].XM7.G0 x1.x1[8].XM7.D0 vdd.t0 sg13_hv_pmos ad=0.38p pd=2.38u as=0.68p ps=4.68u w=2u l=0.5u
X279 x2.outb1p.t9 x2.vbn2 x2.XMOP.G0_0 vss.t297 sg13_hv_nmos ad=0.68p pd=4.68u as=0.68p ps=4.68u w=2u l=4u
X280 x1.xtr.XM0[10].S x1.xtr.XM0[9].S vss.t0 rppd l=3.4u w=1.41u
X281 vss.t95 vss.t95 vss.t95 vss.t109 sg13_hv_nmos ad=0.34p pd=2.68u as=0 ps=0 w=1u l=1u
X282 x1.xtr.XM0[12].S x1.xtr.XM0[11].S vss.t0 rppd l=3.4u w=1.41u
X283 x1.xamp.XM1.S0 x1.xamp.vbp1 vdd.t50 vdd.t6 sg13_hv_pmos ad=0.34p pd=2.68u as=0.34p ps=2.68u w=1u l=1u
X284 vdd.t170 x1.level_shift_0[6].XM7.G0 x1.level_shift_0[6].XM2.D0 vdd.t0 sg13_hv_pmos ad=0.19p pd=1.38u as=0.34p ps=2.68u w=1u l=0.5u
X285 x1.x1[6].out x1.x1[6].XM7.D0 vdd.t90 vdd.t0 sg13_hv_pmos ad=0.38p pd=2.38u as=0.38p ps=2.38u w=2u l=0.5u
X286 x2.XM9.D0_0 x2.XM9.D0_0 x2.outa1n.t34 vdd.t5 sg13_hv_pmos ad=0.34p pd=2.68u as=0.34p ps=2.68u w=1u l=4u
X287 x1.x1[5].XM7.G0 x1.x1[5].XM2.D0 vdd.t162 vdd.t0 sg13_hv_pmos ad=0.34p pd=2.68u as=0.19p ps=1.38u w=1u l=0.5u
X288 vdd.t238 x1.x1[8].XM7.D0 x1.x1[8].out vdd.t0 sg13_hv_pmos ad=0.68p pd=4.68u as=0.38p ps=2.38u w=2u l=0.5u
X289 vdd.t208 x1.x1[8].XM7.G0 x1.x1[8].XM2.D0 vdd.t0 sg13_hv_pmos ad=0.19p pd=1.38u as=0.34p ps=2.68u w=1u l=0.5u
X290 x2.outb1p.t11 x2.vbn2 x2.XMOP.G0_0 vss.t303 sg13_hv_nmos ad=0.68p pd=4.68u as=0.68p ps=4.68u w=2u l=4u
X291 x1.xamp.out1p x1.xres.c x1.xamp.XM1.S0 vdd.t6 sg13_hv_pmos ad=1.36p pd=8.68u as=1.36p ps=8.68u w=4u l=1u
X292 vdd.t231 x1.level_shift_0[2].XM7.D0 x1.level_shift_0[2].out vdd.t0 sg13_hv_pmos ad=0.68p pd=4.68u as=0.38p ps=2.38u w=2u l=0.5u
X293 x2.outb1n.t43 x2.vbn1 vss.t95 vss.t417 sg13_hv_nmos ad=0.34p pd=2.68u as=0.34p ps=2.68u w=1u l=1u
X294 vss.t41 vss.t61 x1.xres.c pnpMPA a=1.4p p=5.4u
**devattr d=249408261,157565
X295 vss.t242 x1.x1[1].XM7.D0 x1.x1[1].out vss.t241 sg13_hv_nmos ad=0.34p pd=2.68u as=0.19p ps=1.38u w=1u l=0.5u
X296 x1.xres.XR1[13].R1 x1.xres.XR1[11].R2 vss.t244 rhigh l=20u w=0.69u
X297 x2.XM9.D0_0 x2.XM9.D0_0 x2.outa1n.t39 vdd.t5 sg13_hv_pmos ad=0.34p pd=2.68u as=0.34p ps=2.68u w=1u l=4u
X298 vdd.t14 x1.level_shift_0[3].XM7.G0 x1.level_shift_0[3].XM7.D0 vdd.t0 sg13_hv_pmos ad=0.38p pd=2.38u as=0.68p ps=4.68u w=2u l=0.5u
X299 x2.outb1p.t44 x2.vbn1 vss.t95 vss.t418 sg13_hv_nmos ad=0.34p pd=2.68u as=0.34p ps=2.68u w=1u l=1u
X300 vss.t132 x1.level_shift_0[3].XM7.D0 x1.level_shift_0[3].out vss.t126 sg13_hv_nmos ad=0.34p pd=2.68u as=0.19p ps=1.38u w=1u l=0.5u
X301 x1.level_shift_0[6].out x1.level_shift_0[6].XM7.D0 vss.t167 vss.t124 sg13_hv_nmos ad=0.19p pd=1.38u as=0.34p ps=2.68u w=1u l=0.5u
X302 x1.level_shift_0[6].XM7.D0 x1.level_shift_0[6].XM7.G0 vss.t167 vss.t131 sg13_hv_nmos ad=0.19p pd=1.38u as=0.34p ps=2.68u w=1u l=0.5u
X303 vss.t7 x1.x1[3].XM7.G0 x1.x1[3].XM7.D0 vss.t263 sg13_hv_nmos ad=0.34p pd=2.68u as=0.19p ps=1.38u w=1u l=0.5u
X304 x2.outb1n.t2 x2.vbn2 x2.XM9.D0_0 vss.t302 sg13_hv_nmos ad=0.68p pd=4.68u as=0.68p ps=4.68u w=2u l=4u
X305 x1.xamp.vbn2 x1.xamp.vbp1 vdd.t34 vdd.t6 sg13_hv_pmos ad=0.34p pd=2.68u as=0.34p ps=2.68u w=1u l=1u
X306 vdd.t115 x1.x1[4].XM7.G0 x1.x1[4].XM2.D0 vdd.t0 sg13_hv_pmos ad=0.19p pd=1.38u as=0.34p ps=2.68u w=1u l=0.5u
X307 x1.x1[7].out x1.x1[7].XM7.D0 vdd.t235 vdd.t0 sg13_hv_pmos ad=0.38p pd=2.38u as=0.38p ps=2.38u w=2u l=0.5u
X308 x1.xamp.out1n x1.xamp.vbn1 vss.t59 vss.t65 sg13_hv_nmos ad=0.34p pd=2.68u as=0.34p ps=2.68u w=1u l=1u
X309 x1.xamp.out1p x1.xamp.vbn1 vss.t59 vss.t77 sg13_hv_nmos ad=0.34p pd=2.68u as=0.34p ps=2.68u w=1u l=1u
X310 vdd.t246 x1.level_shift_0[5].XM7.D0 x1.level_shift_0[5].out vdd.t0 sg13_hv_pmos ad=0.68p pd=4.68u as=0.38p ps=2.38u w=2u l=0.5u
X311 vss.t34 vss.t36 x1.XQ2_7.E pnpMPA a=1.4p p=5.4u
**devattr d=249408261,157565
X312 x1.level_shift_0[0].out x1.level_shift_0[0].XM7.D0 vss.t14 vss.t223 sg13_hv_nmos ad=0.19p pd=1.38u as=0.34p ps=2.68u w=1u l=0.5u
X313 vss.t7 trim[11] x1.x1[3].XM2.D0 vss.t8 sg13_hv_nmos ad=0.76p pd=4.38u as=1.36p ps=8.68u w=4u l=0.5u
X314 x2.diffb x2.vbp1 vdd.t252 vdd.t5 sg13_hv_pmos ad=0.34p pd=2.68u as=0.34p ps=2.68u w=1u l=1u
X315 x2.outb1n.t37 x2.vbn1 vss.t120 vss.t407 sg13_hv_nmos ad=0.34p pd=2.68u as=0.34p ps=2.68u w=1u l=1u
X316 x1.xamp.vbp1 x1.xamp.vbp2 x1.xamp.vbp2 vdd.t6 sg13_hv_pmos ad=0.68p pd=4.68u as=0.68p ps=4.68u w=2u l=4u
X317 x1.level_shift_0[0].XM7.D0 x1.level_shift_0[0].XM7.G0 vss.t14 vss.t223 sg13_hv_nmos ad=0.19p pd=1.38u as=0.34p ps=2.68u w=1u l=0.5u
X318 x1.level_shift_0[4].XM7.G0 x1.level_shift_0[4].in_n vss.t125 vss.t172 sg13_hv_nmos ad=1.36p pd=8.68u as=0.76p ps=4.38u w=4u l=0.5u
X319 x2.diffa x1.vbg x2.outa1p.t3 vss.t25 sg13_hv_nmos ad=0.68p pd=4.68u as=0.68p ps=4.68u w=2u l=1u
X320 vdd.t181 x1.x1[3].XM7.G0 x1.x1[3].XM7.D0 vdd.t0 sg13_hv_pmos ad=0.38p pd=2.38u as=0.68p ps=4.68u w=2u l=0.5u
X321 x2.outa1p.t29 x2.XM9.D0_0 x2.XMOP.G0_0 vdd.t5 sg13_hv_pmos ad=0.34p pd=2.68u as=0.34p ps=2.68u w=1u l=4u
X322 x1.level_shift_0[5].XM7.G0 x1.level_shift_0[5].XM2.D0 vdd.t3 vdd.t0 sg13_hv_pmos ad=0.34p pd=2.68u as=0.19p ps=1.38u w=1u l=0.5u
X323 x1.xtr.XM0[11].S x1.xtr.XM0[10].S vss.t0 rppd l=3.4u w=1.41u
X324 vss.t59 vss.t59 vss.t59 vss.t60 sg13_hv_nmos ad=0.34p pd=2.68u as=0 ps=0 w=1u l=1u
X325 x1.xamp.out1n x1.xamp.vbn1 vss.t59 vss.t65 sg13_hv_nmos ad=0.34p pd=2.68u as=0.34p ps=2.68u w=1u l=1u
X326 x1.xamp.out1p x1.xamp.vbn1 vss.t59 vss.t77 sg13_hv_nmos ad=0.34p pd=2.68u as=0.34p ps=2.68u w=1u l=1u
X327 vss.t111 vss.t111 vss.t111 vss.t116 sg13_hv_nmos ad=0.34p pd=2.68u as=0 ps=0 w=1u l=1u
X328 x1.x1[7].XM7.G0 x1.x1[7].XM2.D0 vdd.t157 vdd.t0 sg13_hv_pmos ad=0.34p pd=2.68u as=0.19p ps=1.38u w=1u l=0.5u
X329 x1.x1[3].XM7.G0 x1.x1[3].in_n vss.t7 vss.t162 sg13_hv_nmos ad=1.36p pd=8.68u as=0.76p ps=4.38u w=4u l=0.5u
X330 x1.xtr.XM0[13].S x1.xtr.XM0[12].S vss.t0 rppd l=3.4u w=1.41u
X331 x2.diffb x1.vbg x2.outb1p.t2 vdd.t5 sg13_hv_pmos ad=1.36p pd=8.68u as=1.36p ps=8.68u w=4u l=1u
X332 vss.t149 x2.XMOP.G0_0 vbg.t7 vss.t146 sg13_hv_nmos ad=1.36p pd=8.68u as=1.36p ps=8.68u w=4u l=4u
X333 vdd.t219 x1.level_shift_0[2].XM7.G0 x1.level_shift_0[2].XM2.D0 vdd.t0 sg13_hv_pmos ad=0.19p pd=1.38u as=0.34p ps=2.68u w=1u l=0.5u
X334 x1.vs1 x1.vs2 vdd.t140 vdd.t101 sg13_hv_pmos ad=0.34p pd=2.68u as=0.34p ps=2.68u w=1u l=1u
X335 x2.diffb vbg.t21 x2.outb1n.t18 vdd.t5 sg13_hv_pmos ad=1.36p pd=8.68u as=1.36p ps=8.68u w=4u l=1u
X336 x1.xtr.XM0[14].S x1.xtr.XM0[13].S vss.t0 rppd l=3.4u w=1.41u
X337 x2.outb1n.t24 x2.vbn1 vss.t120 vss.t405 sg13_hv_nmos ad=0.34p pd=2.68u as=0.34p ps=2.68u w=1u l=1u
X338 vdd.t8 x1.level_shift_0[4].XM7.D0 x1.level_shift_0[4].out vdd.t0 sg13_hv_pmos ad=0.68p pd=4.68u as=0.38p ps=2.38u w=2u l=0.5u
X339 x2.outa1p.t8 x2.outa1n.t58 vdd.t112 vdd.t5 sg13_hv_pmos ad=0.34p pd=2.68u as=0.34p ps=2.68u w=1u l=1u
X340 x2.outb1p.t25 x2.vbn1 vss.t120 vss.t389 sg13_hv_nmos ad=0.34p pd=2.68u as=0.34p ps=2.68u w=1u l=1u
X341 vdd.t24 x1.xamp.XM6.S0 x1.xamp.XM8.S1 vdd.t6 sg13_hv_pmos ad=0.68p pd=4.68u as=0.68p ps=4.68u w=2u l=4u
X342 x1.level_shift_0[7].out x1.level_shift_0[7].XM7.D0 vdd.t88 vdd.t0 sg13_hv_pmos ad=0.38p pd=2.38u as=0.38p ps=2.38u w=2u l=0.5u
X343 x1.xtr.XM0[15].S x1.xtr.XM0[14].S vss.t0 rppd l=3.4u w=1.41u
X344 x1.x1[6].out x1.x1[6].XM7.D0 vss.t122 vss.t156 sg13_hv_nmos ad=0.19p pd=1.38u as=0.34p ps=2.68u w=1u l=0.5u
X345 x1.xres.XR1[10].R1 x1.xres.XR1[8].R2 vss.t161 rhigh l=20u w=0.69u
X346 x2.outb1p.t16 x2.vbn2 x2.XMOP.G0_0 vss.t317 sg13_hv_nmos ad=0.68p pd=4.68u as=0.68p ps=4.68u w=2u l=4u
X347 vdd.t20 x1.xamp.XM6.S0 x1.xamp.XM8.S1 vdd.t6 sg13_hv_pmos ad=0.68p pd=4.68u as=0.68p ps=4.68u w=2u l=4u
X348 vdd.t163 x1.x1[4].XM7.D0 x1.x1[4].out vdd.t0 sg13_hv_pmos ad=0.68p pd=4.68u as=0.38p ps=2.38u w=2u l=0.5u
X349 x1.xtr.top x1.xtr.top vss.t0 rppd l=3.4u w=1.41u
X350 x2.outb1p.t42 x2.vbn1 vss.t95 vss.t414 sg13_hv_nmos ad=0.34p pd=2.68u as=0.34p ps=2.68u w=1u l=1u
X351 x2.diffb vbg.t18 x2.outb1n.t21 vdd.t5 sg13_hv_pmos ad=1.36p pd=8.68u as=1.36p ps=8.68u w=4u l=1u
X352 x2.vbn1 x2.vbn1 vss.t119 vss.t403 sg13_hv_nmos ad=0.34p pd=2.68u as=0.34p ps=2.68u w=1u l=1u
X353 x2.diffa x1.vbg x2.outa1p.t4 vss.t26 sg13_hv_nmos ad=0.68p pd=4.68u as=0.68p ps=4.68u w=2u l=1u
X354 vss.t135 ena x1.x1[0].XM7.G0 vss.t453 sg13_hv_nmos ad=0.76p pd=4.38u as=1.36p ps=8.68u w=4u l=0.5u
X355 x1.x1[8].XM7.G0 x1.x1[8].XM2.D0 vdd.t208 vdd.t0 sg13_hv_pmos ad=0.34p pd=2.68u as=0.19p ps=1.38u w=1u l=0.5u
X356 x2.vbn2 x2.vbp1 vdd.t252 vdd.t5 sg13_hv_pmos ad=0.34p pd=2.68u as=0.34p ps=2.68u w=1u l=1u
X357 x1.xamp.XM1.S0 x1.xamp.vbp1 vdd.t50 vdd.t6 sg13_hv_pmos ad=0.34p pd=2.68u as=0.34p ps=2.68u w=1u l=1u
X358 x1.xamp.vbn1 x1.xamp.vbn2 x1.xamp.vbn2 vss.t180 sg13_hv_nmos ad=0.34p pd=2.68u as=0.34p ps=2.68u w=1u l=4u
X359 x2.outb1n.t42 x2.vbn1 vss.t95 vss.t415 sg13_hv_nmos ad=0.34p pd=2.68u as=0.34p ps=2.68u w=1u l=1u
X360 x2.XMB4.S0 x1.ena_b_h ibias2_1u vdd.t5 sg13_hv_pmos ad=0.34p pd=2.68u as=0.34p ps=2.68u w=1u l=4u
X361 x1.xamp.out1n x1.xamp.vbn1 vss.t59 vss.t65 sg13_hv_nmos ad=0.34p pd=2.68u as=0.34p ps=2.68u w=1u l=1u
X362 x1.xamp.out1p x1.xamp.vbn1 vss.t59 vss.t77 sg13_hv_nmos ad=0.34p pd=2.68u as=0.34p ps=2.68u w=1u l=1u
X363 x2.diffa x2.vbn1 vss.t95 vss.t103 sg13_hv_nmos ad=0.34p pd=2.68u as=0.34p ps=2.68u w=1u l=1u
X364 x1.xamp.out1n x1.xres.d x1.xamp.XM1.S0 vdd.t6 sg13_hv_pmos ad=1.36p pd=8.68u as=1.36p ps=8.68u w=4u l=1u
X365 x1.xamp.XM6.S0 x1.xamp.vbn2 x1.xamp.out1n vss.t181 sg13_hv_nmos ad=0.34p pd=2.68u as=0.34p ps=2.68u w=1u l=4u
X366 x2.diffa x2.vbn1 vss.t95 vss.t105 sg13_hv_nmos ad=0.34p pd=2.68u as=0.34p ps=2.68u w=1u l=1u
X367 vdd.t10 x1.level_shift_0[4].XM7.G0 x1.level_shift_0[4].XM7.D0 vdd.t0 sg13_hv_pmos ad=0.38p pd=2.38u as=0.68p ps=4.68u w=2u l=0.5u
X368 vss.t299 x2.vbn2 vss.t298 vss.t315 sg13_hv_nmos ad=0.68p pd=4.68u as=0 ps=0 w=2u l=4u
X369 x1.x1[2].XM7.D0 x1.x1[2].XM7.G0 vss.t177 vss.t176 sg13_hv_nmos ad=0.19p pd=1.38u as=0.34p ps=2.68u w=1u l=0.5u
X370 x1.level_shift_0[7].out x1.level_shift_0[7].XM7.D0 vss.t58 vss.t124 sg13_hv_nmos ad=0.19p pd=1.38u as=0.34p ps=2.68u w=1u l=0.5u
X371 x1.level_shift_0[7].XM7.D0 x1.level_shift_0[7].XM7.G0 vss.t58 vss.t131 sg13_hv_nmos ad=0.19p pd=1.38u as=0.34p ps=2.68u w=1u l=0.5u
X372 vss.t59 vss.t59 vss.t59 vss.t75 sg13_hv_nmos ad=0.34p pd=2.68u as=0 ps=0 w=1u l=1u
X373 x2.outb1n.t29 x2.vbn1 vss.t95 vss.t387 sg13_hv_nmos ad=0.34p pd=2.68u as=0.34p ps=2.68u w=1u l=1u
X374 vdd.t161 x1.x1[5].XM7.G0 x1.x1[5].XM2.D0 vdd.t0 sg13_hv_pmos ad=0.19p pd=1.38u as=0.34p ps=2.68u w=1u l=0.5u
X375 x1.xres.XR1[1].R1 x1.xres.XR1[3].R2 vss.t336 rhigh l=20u w=0.69u
X376 x2.vbp1 x2.vbp1 vdd.t121 vdd.t5 sg13_hv_pmos ad=0.34p pd=2.68u as=0.34p ps=2.68u w=1u l=1u
X377 vss.t259 trim[10] x1.level_shift_0[2].XM2.D0 vss.t347 sg13_hv_nmos ad=0.76p pd=4.38u as=1.36p ps=8.68u w=4u l=0.5u
X378 x1.xamp.out1p x1.xamp.vbn1 vss.t59 vss.t65 sg13_hv_nmos ad=0.34p pd=2.68u as=0.34p ps=2.68u w=1u l=1u
X379 vss.t18 x1.x1[8].in_n x1.x1[8].XM7.G0 vss.t19 sg13_hv_nmos ad=0.76p pd=4.38u as=1.36p ps=8.68u w=4u l=0.5u
X380 vss.t7 x1.x1[3].XM7.D0 x1.x1[3].out vss.t263 sg13_hv_nmos ad=0.34p pd=2.68u as=0.19p ps=1.38u w=1u l=0.5u
X381 x1.x1[1].XM2.D0 trim[15] vss.t135 vss.t249 sg13_hv_nmos ad=1.36p pd=8.68u as=0.76p ps=4.38u w=4u l=0.5u
X382 x1.xamp.out1n x1.xamp.vbn1 vss.t59 vss.t77 sg13_hv_nmos ad=0.34p pd=2.68u as=0.34p ps=2.68u w=1u l=1u
X383 x1.xamp.XM1.S0 x1.xamp.vbp1 vdd.t6 vdd.t6 sg13_hv_pmos ad=0.34p pd=2.68u as=0.34p ps=2.68u w=1u l=1u
X384 vss.t11 x1.x1[5].XM7.D0 x1.x1[5].out vss.t247 sg13_hv_nmos ad=0.34p pd=2.68u as=0.19p ps=1.38u w=1u l=0.5u
X385 vss.t167 x1.level_shift_0[5].XM7.D0 x1.level_shift_0[5].out vss.t124 sg13_hv_nmos ad=0.34p pd=2.68u as=0.19p ps=1.38u w=1u l=0.5u
X386 x1.level_shift_0[2].out x1.level_shift_0[2].XM7.D0 vss.t276 vss.t344 sg13_hv_nmos ad=0.19p pd=1.38u as=0.34p ps=2.68u w=1u l=0.5u
X387 vss.t7 trim[9] x1.x1[4].XM2.D0 vss.t140 sg13_hv_nmos ad=0.76p pd=4.38u as=1.36p ps=8.68u w=4u l=0.5u
X388 x2.outb1p.t47 x2.vbn1 vss.t95 vss.t424 sg13_hv_nmos ad=0.34p pd=2.68u as=0.34p ps=2.68u w=1u l=1u
X389 x2.outb1n.t0 x2.vbn2 x2.XM9.D0_0 vss.t297 sg13_hv_nmos ad=0.68p pd=4.68u as=0.68p ps=4.68u w=2u l=4u
X390 vss.t167 x1.level_shift_0[5].XM7.G0 x1.level_shift_0[5].XM7.D0 vss.t131 sg13_hv_nmos ad=0.34p pd=2.68u as=0.19p ps=1.38u w=1u l=0.5u
X391 x1.xamp.vbp1 x1.xamp.vbp1 vdd.t6 vdd.t6 sg13_hv_pmos ad=0.34p pd=2.68u as=0.34p ps=2.68u w=1u l=1u
X392 x1.x1[1].out x1.x1[1].XM7.D0 vdd.t154 vdd.t0 sg13_hv_pmos ad=0.38p pd=2.38u as=0.38p ps=2.38u w=2u l=0.5u
X393 vss.t135 x1.x1[0].XM7.G0 x1.x1[0].XM7.D0 vss.t134 sg13_hv_nmos ad=0.34p pd=2.68u as=0.19p ps=1.38u w=1u l=0.5u
X394 x2.outb1n.t47 x2.vbn1 vss.t95 vss.t425 sg13_hv_nmos ad=0.34p pd=2.68u as=0.34p ps=2.68u w=1u l=1u
X395 vdd.t50 vdd.t50 vdd.t50 vdd.t6 sg13_hv_pmos ad=1.36p pd=8.68u as=0 ps=0 w=4u l=1u
X396 vdd.t232 x1.level_shift_0[2].XM7.G0 x1.level_shift_0[2].XM7.D0 vdd.t0 sg13_hv_pmos ad=0.38p pd=2.38u as=0.68p ps=4.68u w=2u l=0.5u
X397 x1.xres.XR1[1].R1 x1.XM1.S0 vss.t363 rhigh l=20u w=0.69u
X398 x2.diffb x2.vbp1 vdd.t252 vdd.t5 sg13_hv_pmos ad=0.34p pd=2.68u as=0.34p ps=2.68u w=1u l=1u
X399 x2.XM9.D0_0 x2.XM9.D0_0 x2.outa1n.t29 vdd.t5 sg13_hv_pmos ad=0.34p pd=2.68u as=0.34p ps=2.68u w=1u l=4u
X400 x1.level_shift_0[0].XM7.G0 x1.level_shift_0[0].XM2.D0 vdd.t199 vdd.t0 sg13_hv_pmos ad=0.34p pd=2.68u as=0.19p ps=1.38u w=1u l=0.5u
X401 x2.outb1p.t34 x2.vbn1 vss.t95 vss.t422 sg13_hv_nmos ad=0.34p pd=2.68u as=0.34p ps=2.68u w=1u l=1u
X402 vss.t95 vss.t95 vss.t95 vss.t27 sg13_hv_nmos ad=0.34p pd=2.68u as=0 ps=0 w=1u l=1u
X403 x1.xamp.vbp1 x1.xamp.vbp2 x1.xamp.vbp2 vdd.t6 sg13_hv_pmos ad=0.68p pd=4.68u as=0.68p ps=4.68u w=2u l=4u
X404 vdd.t247 x1.level_shift_0[5].XM7.D0 x1.level_shift_0[5].out vdd.t0 sg13_hv_pmos ad=0.68p pd=4.68u as=0.38p ps=2.38u w=2u l=0.5u
X405 x2.outa1p.t31 x2.XM9.D0_0 x2.XMOP.G0_0 vdd.t5 sg13_hv_pmos ad=0.34p pd=2.68u as=0.34p ps=2.68u w=1u l=4u
X406 vss.t58 x1.level_shift_0[6].XM7.D0 x1.level_shift_0[6].out vss.t124 sg13_hv_nmos ad=0.34p pd=2.68u as=0.19p ps=1.38u w=1u l=0.5u
X407 x2.outb1n.t11 x2.vbn2 x2.XM9.D0_0 vss.t324 sg13_hv_nmos ad=0.68p pd=4.68u as=0.68p ps=4.68u w=2u l=4u
X408 x2.outb1n.t34 x2.vbn1 vss.t95 vss.t388 sg13_hv_nmos ad=0.34p pd=2.68u as=0.34p ps=2.68u w=1u l=1u
X409 vss.t58 x1.level_shift_0[6].XM7.G0 x1.level_shift_0[6].XM7.D0 vss.t131 sg13_hv_nmos ad=0.34p pd=2.68u as=0.19p ps=1.38u w=1u l=0.5u
X410 vdd.t29 x1.xamp.XM6.S0 x1.xamp.XM8.S1 vdd.t6 sg13_hv_pmos ad=0.68p pd=4.68u as=0.68p ps=4.68u w=2u l=4u
X411 x1.xres.XR1[14].R1 x1.xres.XR1[12].R2 vss.t225 rhigh l=20u w=0.69u
X412 x1.xamp.out1n x1.xres.d x1.xamp.XM1.S0 vdd.t6 sg13_hv_pmos ad=1.36p pd=8.68u as=1.36p ps=8.68u w=4u l=1u
X413 x1.x1[4].XM7.D0 x1.x1[4].XM7.G0 vss.t171 vss.t170 sg13_hv_nmos ad=0.19p pd=1.38u as=0.34p ps=2.68u w=1u l=0.5u
X414 x2.outa1p.t17 x2.XM9.D0_0 x2.XMOP.G0_0 vdd.t5 sg13_hv_pmos ad=0.34p pd=2.68u as=0.34p ps=2.68u w=1u l=4u
X415 x1.level_shift_0[3].XM7.G0 x1.level_shift_0[3].XM2.D0 vdd.t16 vdd.t0 sg13_hv_pmos ad=0.34p pd=2.68u as=0.19p ps=1.38u w=1u l=0.5u
X416 x2.outb1p.t10 x2.vbn2 x2.XMOP.G0_0 vss.t301 sg13_hv_nmos ad=0.68p pd=4.68u as=0.68p ps=4.68u w=2u l=4u
X417 vss.t41 vss.t40 x1.XQ2_7.E pnpMPA a=1.4p p=5.4u
**devattr d=249408261,157565
X418 x1.xamp.vbn1 x1.xamp.vbn1 vss.t59 vss.t65 sg13_hv_nmos ad=0.34p pd=2.68u as=0.34p ps=2.68u w=1u l=1u
X419 x2.outb1n.t27 x2.vbn1 vss.t391 vss.t409 sg13_hv_nmos ad=0.34p pd=2.68u as=0.34p ps=2.68u w=1u l=1u
X420 x2.outb1p.t28 x2.vbn1 vss.t391 vss.t390 sg13_hv_nmos ad=0.34p pd=2.68u as=0.34p ps=2.68u w=1u l=1u
X421 x2.outa1n.t15 x2.outa1n.t14 vdd.t5 vdd.t5 sg13_hv_pmos ad=0.34p pd=2.68u as=0.34p ps=2.68u w=1u l=1u
X422 vdd.t152 x1.x1[0].XM7.G0 x1.x1[0].XM2.D0 vdd.t0 sg13_hv_pmos ad=0.19p pd=1.38u as=0.34p ps=2.68u w=1u l=0.5u
X423 vss.t11 trim[5] x1.x1[6].XM2.D0 vss.t340 sg13_hv_nmos ad=0.76p pd=4.38u as=1.36p ps=8.68u w=4u l=0.5u
X424 x1.x1[3].out x1.x1[3].XM7.D0 vdd.t180 vdd.t0 sg13_hv_pmos ad=0.38p pd=2.38u as=0.38p ps=2.38u w=2u l=0.5u
X425 x1.xamp.vbn1 x1.xamp.vbn1 vss.t59 vss.t65 sg13_hv_nmos ad=0.34p pd=2.68u as=0.34p ps=2.68u w=1u l=1u
X426 x1.x1[2].XM7.G0 x1.x1[2].XM2.D0 vdd.t138 vdd.t0 sg13_hv_pmos ad=0.34p pd=2.68u as=0.19p ps=1.38u w=1u l=0.5u
X427 vdd.t18 x1.xamp.XM6.S0 x1.xamp.XM8.D0 vdd.t6 sg13_hv_pmos ad=0.68p pd=4.68u as=0.68p ps=4.68u w=2u l=4u
X428 vdd.t91 x1.x1[6].XM7.G0 x1.x1[6].XM7.D0 vdd.t0 sg13_hv_pmos ad=0.38p pd=2.38u as=0.68p ps=4.68u w=2u l=0.5u
X429 x2.XM9.D0_0 x2.XM9.D0_0 x2.outa1n.t36 vdd.t5 sg13_hv_pmos ad=0.34p pd=2.68u as=0.34p ps=2.68u w=1u l=4u
X430 x1.x1[5].XM7.D0 x1.x1[5].XM7.G0 vss.t11 vss.t248 sg13_hv_nmos ad=0.19p pd=1.38u as=0.34p ps=2.68u w=1u l=0.5u
X431 x1.xamp.out1p x1.xamp.vbn1 vss.t59 vss.t65 sg13_hv_nmos ad=0.34p pd=2.68u as=0.34p ps=2.68u w=1u l=1u
X432 x1.level_shift_0[2].XM7.G0 x1.level_shift_0[2].in_n vss.t276 vss.t275 sg13_hv_nmos ad=1.36p pd=8.68u as=0.76p ps=4.38u w=4u l=0.5u
X433 x1.xamp.out1n x1.xamp.vbn1 vss.t59 vss.t77 sg13_hv_nmos ad=0.34p pd=2.68u as=0.34p ps=2.68u w=1u l=1u
X434 vss.t34 vss.t33 x1.XQ2_7.E pnpMPA a=1.4p p=5.4u
**devattr d=249408261,157565
X435 x1.level_shift_0[0].XM2.D0 trim[14] vss.t14 vss.t13 sg13_hv_nmos ad=1.36p pd=8.68u as=0.76p ps=4.38u w=4u l=0.5u
X436 x1.x1[2].out x1.x1[2].XM7.D0 vss.t177 vss.t176 sg13_hv_nmos ad=0.19p pd=1.38u as=0.34p ps=2.68u w=1u l=0.5u
X437 x1.x1[6].XM7.G0 x1.x1[6].in_n vss.t122 vss.t121 sg13_hv_nmos ad=1.36p pd=8.68u as=0.76p ps=4.38u w=4u l=0.5u
X438 vss.t31 trim[8] x1.level_shift_0[3].XM2.D0 vss.t30 sg13_hv_nmos ad=0.76p pd=4.38u as=1.36p ps=8.68u w=4u l=0.5u
X439 vss.t14 x1.level_shift_0[0].XM7.D0 x1.level_shift_0[0].out vss.t221 sg13_hv_nmos ad=0.34p pd=2.68u as=0.19p ps=1.38u w=1u l=0.5u
X440 vdd.t4 x1.level_shift_0[5].XM7.G0 x1.level_shift_0[5].XM2.D0 vdd.t0 sg13_hv_pmos ad=0.19p pd=1.38u as=0.34p ps=2.68u w=1u l=0.5u
X441 x1.XM1.G0 x1.xamp.vbp2 x1.xamp.XM8.D0 vdd.t6 sg13_hv_pmos ad=0.68p pd=4.68u as=0.68p ps=4.68u w=2u l=4u
X442 x1.x1[4].XM2.D0 trim[9] vss.t7 vss.t139 sg13_hv_nmos ad=1.36p pd=8.68u as=0.76p ps=4.38u w=4u l=0.5u
X443 x2.vbp1 x2.XMB4.S0 x2.XMB4.S0 vdd.t5 sg13_hv_pmos ad=0.34p pd=2.68u as=0.34p ps=2.68u w=1u l=4u
X444 vdd.t59 x1.x1[0].XM7.G0 x1.x1[0].XM7.D0 vdd.t0 sg13_hv_pmos ad=0.38p pd=2.38u as=0.68p ps=4.68u w=2u l=0.5u
X445 x1.level_shift_0[0].out x1.level_shift_0[0].XM7.D0 vdd.t147 vdd.t0 sg13_hv_pmos ad=0.38p pd=2.38u as=0.38p ps=2.38u w=2u l=0.5u
X446 x2.outb1n.t32 x2.vbn1 vss.t95 vss.t419 sg13_hv_nmos ad=0.34p pd=2.68u as=0.34p ps=2.68u w=1u l=1u
X447 vss.t18 x1.x1[8].XM7.G0 x1.x1[8].XM7.D0 vss.t295 sg13_hv_nmos ad=0.34p pd=2.68u as=0.19p ps=1.38u w=1u l=0.5u
X448 vss.t95 vss.t95 vss.t95 vss.t96 sg13_hv_nmos ad=0.34p pd=2.68u as=0 ps=0 w=1u l=1u
X449 vss.t135 x1.x1[0].XM7.D0 x1.ena_b_h vss.t134 sg13_hv_nmos ad=0.34p pd=2.68u as=0.19p ps=1.38u w=1u l=0.5u
X450 x1.xamp.XM1.S0 x1.xamp.vbp1 vdd.t6 vdd.t6 sg13_hv_pmos ad=0.34p pd=2.68u as=0.34p ps=2.68u w=1u l=1u
X451 vss.t58 vss.t55 vss.t57 vss.t56 sg13_hv_nmos ad=0.68p pd=4.68u as=0 ps=0 w=2u l=0.5u
X452 x1.xres.XR1[9].R1 x1.xres.XR1[11].R2 vss.t16 rhigh l=20u w=0.69u
X453 x1.xres.XR1[17].R1 x1.xres.XR1[15].R2 vss.t228 rhigh l=20u w=0.69u
X454 x2.outb1p.t33 x2.vbn1 vss.t95 vss.t421 sg13_hv_nmos ad=0.34p pd=2.68u as=0.34p ps=2.68u w=1u l=1u
X455 x1.xamp.vbn2 x1.xamp.vbp1 vdd.t6 vdd.t6 sg13_hv_pmos ad=0.34p pd=2.68u as=0.34p ps=2.68u w=1u l=1u
X456 vdd.t58 x1.x1[0].XM7.D0 x1.ena_b_h vdd.t0 sg13_hv_pmos ad=0.68p pd=4.68u as=0.38p ps=2.38u w=2u l=0.5u
X457 x2.vbp1 x2.XMB4.S0 x2.XMB4.S0 vdd.t5 sg13_hv_pmos ad=0.34p pd=2.68u as=0.34p ps=2.68u w=1u l=4u
X458 x1.XQ2_7.E x1.level_shift_0[7].out x1.xtr.XM0[1].S vss.t56 sg13_hv_nmos ad=0.68p pd=4.68u as=0.68p ps=4.68u w=2u l=0.5u
X459 x2.diffb x2.vbp1 vdd.t252 vdd.t5 sg13_hv_pmos ad=0.34p pd=2.68u as=0.34p ps=2.68u w=1u l=1u
X460 x1.x1[5].out x1.x1[5].XM7.D0 vdd.t160 vdd.t0 sg13_hv_pmos ad=0.38p pd=2.38u as=0.38p ps=2.38u w=2u l=0.5u
X461 vss.t53 vss.t52 x1.XQ2_7.E pnpMPA a=1.4p p=5.4u
**devattr d=249408261,157565
X462 x1.XQ2_7.E x1.x1[8].out x1.xtr.XM0[2].S vss.t56 sg13_hv_nmos ad=0.68p pd=4.68u as=0.68p ps=4.68u w=2u l=0.5u
X463 x2.diffb x2.vbp1 vdd.t252 vdd.t5 sg13_hv_pmos ad=0.34p pd=2.68u as=0.34p ps=2.68u w=1u l=1u
X464 vdd.t289 x1.x1[7].XM7.D0 x1.x1[7].out vdd.t0 sg13_hv_pmos ad=0.68p pd=4.68u as=0.38p ps=2.38u w=2u l=0.5u
X465 x2.XM9.D0_0 x2.XM9.D0_0 x2.outa1n.t31 vdd.t5 sg13_hv_pmos ad=0.34p pd=2.68u as=0.34p ps=2.68u w=1u l=4u
X466 x1.xamp.out1n x1.xres.d x1.xamp.XM1.S0 vdd.t6 sg13_hv_pmos ad=1.36p pd=8.68u as=1.36p ps=8.68u w=4u l=1u
X467 vdd.t158 x1.x1[7].XM7.G0 x1.x1[7].XM2.D0 vdd.t0 sg13_hv_pmos ad=0.19p pd=1.38u as=0.34p ps=2.68u w=1u l=0.5u
X468 x1.level_shift_0[4].XM7.G0 x1.level_shift_0[4].XM2.D0 vdd.t2 vdd.t0 sg13_hv_pmos ad=0.34p pd=2.68u as=0.19p ps=1.38u w=1u l=0.5u
X469 vdd.t233 x1.level_shift_0[2].XM7.G0 x1.level_shift_0[2].XM7.D0 vdd.t0 sg13_hv_pmos ad=0.38p pd=2.38u as=0.68p ps=4.68u w=2u l=0.5u
X470 x2.diffb vbg.t16 x2.outb1n.t23 vdd.t5 sg13_hv_pmos ad=1.36p pd=8.68u as=1.36p ps=8.68u w=4u l=1u
X471 x1.x1[4].out x1.x1[4].XM7.D0 vss.t171 vss.t170 sg13_hv_nmos ad=0.19p pd=1.38u as=0.34p ps=2.68u w=1u l=0.5u
X472 x2.vbn2 x2.vbp1 vdd.t252 vdd.t5 sg13_hv_pmos ad=0.34p pd=2.68u as=0.34p ps=2.68u w=1u l=1u
X473 x1.xamp.out1n x1.xamp.vbn1 vss.t59 vss.t65 sg13_hv_nmos ad=0.34p pd=2.68u as=0.34p ps=2.68u w=1u l=1u
X474 x1.xamp.XM6.S0 x1.xamp.vbn2 x1.xamp.out1n vss.t180 sg13_hv_nmos ad=0.34p pd=2.68u as=0.34p ps=2.68u w=1u l=4u
X475 vss.t58 x1.level_shift_0[7].in_n x1.level_shift_0[7].XM7.G0 vss.t172 sg13_hv_nmos ad=0.76p pd=4.38u as=1.36p ps=8.68u w=4u l=0.5u
X476 x1.xamp.out1p x1.xamp.vbn1 vss.t59 vss.t77 sg13_hv_nmos ad=0.34p pd=2.68u as=0.34p ps=2.68u w=1u l=1u
X477 x2.outb1p.t21 x2.vbn2 x2.XMOP.G0_0 vss.t320 sg13_hv_nmos ad=0.68p pd=4.68u as=0.68p ps=4.68u w=2u l=4u
X478 x1.xamp.out1p x1.xres.c x1.xamp.XM1.S0 vdd.t6 sg13_hv_pmos ad=1.36p pd=8.68u as=1.36p ps=8.68u w=4u l=1u
X479 vss.t125 trim[4] x1.level_shift_0[5].XM2.D0 vss.t239 sg13_hv_nmos ad=0.76p pd=4.38u as=1.36p ps=8.68u w=4u l=0.5u
X480 x2.outa1n.t1 x2.outa1n.t0 vdd.t121 vdd.t5 sg13_hv_pmos ad=0.34p pd=2.68u as=0.34p ps=2.68u w=1u l=1u
X481 vdd.t132 x1.x1[2].XM7.G0 x1.x1[2].XM7.D0 vdd.t0 sg13_hv_pmos ad=0.38p pd=2.38u as=0.68p ps=4.68u w=2u l=0.5u
X482 x1.level_shift_0[5].out x1.level_shift_0[5].XM7.D0 vss.t271 vss.t126 sg13_hv_nmos ad=0.19p pd=1.38u as=0.34p ps=2.68u w=1u l=0.5u
X483 x2.diffb x2.vbp1 vdd.t252 vdd.t5 sg13_hv_pmos ad=0.34p pd=2.68u as=0.34p ps=2.68u w=1u l=1u
X484 x2.outb1n.t4 x2.vbn2 x2.XM9.D0_0 vss.t307 sg13_hv_nmos ad=0.68p pd=4.68u as=0.68p ps=4.68u w=2u l=4u
X485 x2.outa1p.t19 x2.XM9.D0_0 x2.XMOP.G0_0 vdd.t5 sg13_hv_pmos ad=0.34p pd=2.68u as=0.34p ps=2.68u w=1u l=4u
X486 x1.XM1.G0 x1.xamp.vbn2 x1.xamp.out1p vss.t180 sg13_hv_nmos ad=0.34p pd=2.68u as=0.34p ps=2.68u w=1u l=4u
X487 x1.x1[4].out x1.x1[4].XM7.D0 vdd.t114 vdd.t0 sg13_hv_pmos ad=0.38p pd=2.38u as=0.38p ps=2.38u w=2u l=0.5u
X488 x2.XM9.D0_0 x2.XM9.D0_0 x2.outa1n.t32 vdd.t5 sg13_hv_pmos ad=0.34p pd=2.68u as=0.34p ps=2.68u w=1u l=4u
X489 vss.t59 vss.t59 vss.t59 vss.t77 sg13_hv_nmos ad=0.34p pd=2.68u as=0 ps=0 w=1u l=1u
X490 vdd.t193 x1.level_shift_0[5].XM7.G0 x1.level_shift_0[5].XM7.D0 vdd.t0 sg13_hv_pmos ad=0.38p pd=2.38u as=0.68p ps=4.68u w=2u l=0.5u
X491 x1.xamp.vbp1 x1.xamp.vbp2 x1.xamp.vbp2 vdd.t6 sg13_hv_pmos ad=0.68p pd=4.68u as=0.68p ps=4.68u w=2u l=4u
X492 vss.t4 vss.t5 vss.t3 rhigh l=20u w=0.69u
X493 x2.outa1p.t21 x2.XM9.D0_0 x2.XMOP.G0_0 vdd.t5 sg13_hv_pmos ad=0.34p pd=2.68u as=0.34p ps=2.68u w=1u l=4u
X494 vdd.t198 x1.level_shift_0[0].XM7.G0 x1.level_shift_0[0].XM2.D0 vdd.t0 sg13_hv_pmos ad=0.19p pd=1.38u as=0.34p ps=2.68u w=1u l=0.5u
X495 x2.diffa x2.vbn1 vss.t95 vss.t26 sg13_hv_nmos ad=0.34p pd=2.68u as=0.34p ps=2.68u w=1u l=1u
X496 x1.x1[5].out x1.x1[5].XM7.D0 vss.t11 vss.t248 sg13_hv_nmos ad=0.19p pd=1.38u as=0.34p ps=2.68u w=1u l=0.5u
X497 x1.level_shift_0[3].XM2.D0 trim[8] vss.t31 vss.t30 sg13_hv_nmos ad=1.36p pd=8.68u as=0.76p ps=4.38u w=4u l=0.5u
X498 vdd.t130 x1.x1[2].XM7.D0 x1.x1[2].out vdd.t0 sg13_hv_pmos ad=0.68p pd=4.68u as=0.38p ps=2.38u w=2u l=0.5u
X499 vss.t59 vss.t59 vss.t59 vss.t65 sg13_hv_nmos ad=0.34p pd=2.68u as=0 ps=0 w=1u l=1u
X500 x2.diffb vbg.t22 x2.outb1n.t17 vdd.t5 sg13_hv_pmos ad=1.36p pd=8.68u as=1.36p ps=8.68u w=4u l=1u
X501 x1.level_shift_0[2].XM7.G0 x1.level_shift_0[2].XM2.D0 vdd.t218 vdd.t0 sg13_hv_pmos ad=0.34p pd=2.68u as=0.19p ps=1.38u w=1u l=0.5u
X502 x2.outa1n.t21 x2.outa1n.t20 vdd.t5 vdd.t5 sg13_hv_pmos ad=0.34p pd=2.68u as=0.34p ps=2.68u w=1u l=1u
X503 vss.t299 x2.vbn2 vss.t298 vss.t305 sg13_hv_nmos ad=0.68p pd=4.68u as=0 ps=0 w=2u l=4u
X504 vss.t11 x1.x1[4].XM7.G0 x1.x1[4].XM7.D0 vss.t169 sg13_hv_nmos ad=0.34p pd=2.68u as=0.19p ps=1.38u w=1u l=0.5u
X505 x2.XM9.D0_0 x2.XM9.D0_0 x2.outa1n.t38 vdd.t5 sg13_hv_pmos ad=0.34p pd=2.68u as=0.34p ps=2.68u w=1u l=4u
X506 x1.vbg x1.XM1.G0 vdd.t104 vdd.t101 sg13_hv_pmos ad=1.36p pd=8.68u as=1.36p ps=8.68u w=4u l=1u
X507 x2.outa1p.t10 x2.outa1n.t49 vdd.t5 vdd.t5 sg13_hv_pmos ad=0.34p pd=2.68u as=0.34p ps=2.68u w=1u l=1u
X508 x1.x1[6].XM7.G0 x1.x1[6].XM2.D0 vdd.t92 vdd.t0 sg13_hv_pmos ad=0.34p pd=2.68u as=0.19p ps=1.38u w=1u l=0.5u
X509 x1.xamp.XM6.S0 x1.xamp.vbn2 x1.xamp.out1n vss.t180 sg13_hv_nmos ad=0.34p pd=2.68u as=0.34p ps=2.68u w=1u l=4u
X510 x2.outa1p.t9 x2.outa1n.t55 vdd.t99 vdd.t5 sg13_hv_pmos ad=0.34p pd=2.68u as=0.34p ps=2.68u w=1u l=1u
X511 x2.outb1p.t38 x2.vbn1 vss.t120 vss.t408 sg13_hv_nmos ad=0.34p pd=2.68u as=0.34p ps=2.68u w=1u l=1u
X512 x2.diffb x2.vbp1 vdd.t252 vdd.t5 sg13_hv_pmos ad=0.34p pd=2.68u as=0.34p ps=2.68u w=1u l=1u
X513 x2.vbn2 x2.vbn2 x2.vbn1 vss.t316 sg13_hv_nmos ad=0.68p pd=4.68u as=0.68p ps=4.68u w=2u l=4u
X514 x2.XM9.D0_0 x2.XM9.D0_0 x2.outa1n.t25 vdd.t5 sg13_hv_pmos ad=0.34p pd=2.68u as=0.34p ps=2.68u w=1u l=4u
X515 x2.outa1n.t11 x2.outa1n.t10 vdd.t5 vdd.t5 sg13_hv_pmos ad=0.34p pd=2.68u as=0.34p ps=2.68u w=1u l=1u
X516 x1.XM1.G0 x1.vs1 vss.t21 vss.t358 sg13_hv_nmos ad=0.34p pd=2.68u as=0.34p ps=2.68u w=1u l=1u
X517 vss.t7 x1.x1[2].XM7.D0 x1.x1[2].out vss.t174 sg13_hv_nmos ad=0.34p pd=2.68u as=0.19p ps=1.38u w=1u l=0.5u
X518 vss.t31 x1.level_shift_0[2].XM7.D0 x1.level_shift_0[2].out vss.t342 sg13_hv_nmos ad=0.34p pd=2.68u as=0.19p ps=1.38u w=1u l=0.5u
X519 x1.xres.XR1[13].R1 x1.xres.XR1[15].R2 vss.t378 rhigh l=20u w=0.69u
X520 x1.xamp.XM1.S0 x1.xamp.vbp1 vdd.t50 vdd.t6 sg13_hv_pmos ad=0.34p pd=2.68u as=0.34p ps=2.68u w=1u l=1u
X521 vdd.t30 x1.xamp.XM6.S0 x1.xamp.XM8.D0 vdd.t6 sg13_hv_pmos ad=0.68p pd=4.68u as=0.68p ps=4.68u w=2u l=4u
X522 x1.XQ2_7.E x1.level_shift_0[5].out x1.xtr.XM0[5].S vss.t56 sg13_hv_nmos ad=0.68p pd=4.68u as=0.68p ps=4.68u w=2u l=0.5u
X523 vss.t31 x1.level_shift_0[2].XM7.G0 x1.level_shift_0[2].XM7.D0 vss.t342 sg13_hv_nmos ad=0.34p pd=2.68u as=0.19p ps=1.38u w=1u l=0.5u
X524 vdd.t97 x1.level_shift_0[1].XM7.G0 x1.level_shift_0[1].XM2.D0 vdd.t0 sg13_hv_pmos ad=0.19p pd=1.38u as=0.34p ps=2.68u w=1u l=0.5u
X525 x2.outb1n.t38 x2.vbn1 vss.t391 vss.t410 sg13_hv_nmos ad=0.34p pd=2.68u as=0.34p ps=2.68u w=1u l=1u
X526 x1.x1[0].XM7.G0 x1.x1[0].XM2.D0 vdd.t151 vdd.t0 sg13_hv_pmos ad=0.34p pd=2.68u as=0.19p ps=1.38u w=1u l=0.5u
X527 vss.t18 x1.x1[8].XM7.D0 x1.x1[8].out vss.t295 sg13_hv_nmos ad=0.34p pd=2.68u as=0.19p ps=1.38u w=1u l=0.5u
X528 vss.t125 x1.level_shift_0[4].XM7.D0 x1.level_shift_0[4].out vss.t126 sg13_hv_nmos ad=0.34p pd=2.68u as=0.19p ps=1.38u w=1u l=0.5u
X529 vdd.t178 x1.x1[3].XM7.D0 x1.x1[3].out vdd.t0 sg13_hv_pmos ad=0.68p pd=4.68u as=0.38p ps=2.38u w=2u l=0.5u
X530 x1.xamp.XM6.S0 x1.xamp.vbp2 x1.xamp.XM8.S1 vdd.t6 sg13_hv_pmos ad=0.68p pd=4.68u as=0.68p ps=4.68u w=2u l=4u
X531 vdd.t125 x1.x1[3].XM7.G0 x1.x1[3].XM2.D0 vdd.t0 sg13_hv_pmos ad=0.19p pd=1.38u as=0.34p ps=2.68u w=1u l=0.5u
X532 vdd.t113 x1.x1[4].XM7.G0 x1.x1[4].XM7.D0 vdd.t0 sg13_hv_pmos ad=0.38p pd=2.38u as=0.68p ps=4.68u w=2u l=0.5u
X533 x1.level_shift_0[4].out x1.level_shift_0[4].XM7.D0 vdd.t9 vdd.t0 sg13_hv_pmos ad=0.38p pd=2.38u as=0.38p ps=2.38u w=2u l=0.5u
X534 x2.diffa vbg.t15 x2.outa1n.t40 vss.t348 sg13_hv_nmos ad=0.68p pd=4.68u as=0.68p ps=4.68u w=2u l=1u
X535 x1.xamp.XM1.S0 x1.xamp.vbp1 vdd.t6 vdd.t6 sg13_hv_pmos ad=0.34p pd=2.68u as=0.34p ps=2.68u w=1u l=1u
X536 vdd.t108 x1.level_shift_0[6].XM7.D0 x1.level_shift_0[6].out vdd.t0 sg13_hv_pmos ad=0.68p pd=4.68u as=0.38p ps=2.38u w=2u l=0.5u
X537 x1.level_shift_0[0].out x1.level_shift_0[0].XM7.D0 vdd.t148 vdd.t0 sg13_hv_pmos ad=0.38p pd=2.38u as=0.38p ps=2.38u w=2u l=0.5u
X538 x1.xamp.out1n x1.xres.d x1.xamp.XM1.S0 vdd.t6 sg13_hv_pmos ad=1.36p pd=8.68u as=1.36p ps=8.68u w=4u l=1u
X539 x2.diffb x2.vbp1 vdd.t252 vdd.t5 sg13_hv_pmos ad=0.34p pd=2.68u as=0.34p ps=2.68u w=1u l=1u
X540 x1.level_shift_0[5].XM7.G0 x1.level_shift_0[5].in_n vss.t271 vss.t172 sg13_hv_nmos ad=1.36p pd=8.68u as=0.76p ps=4.38u w=4u l=0.5u
X541 x1.ena_b_h x1.x1[0].XM7.D0 vdd.t59 vdd.t0 sg13_hv_pmos ad=0.38p pd=2.38u as=0.38p ps=2.38u w=2u l=0.5u
X542 x2.outb1p.t15 x2.vbn2 x2.XMOP.G0_0 vss.t314 sg13_hv_nmos ad=0.68p pd=4.68u as=0.68p ps=4.68u w=2u l=4u
X543 x2.outb1p.t43 x2.vbn1 vss.t95 vss.t416 sg13_hv_nmos ad=0.34p pd=2.68u as=0.34p ps=2.68u w=1u l=1u
X544 x1.xamp.XM6.S0 x1.xamp.vbp2 x1.xamp.XM8.S1 vdd.t6 sg13_hv_pmos ad=0.68p pd=4.68u as=0.68p ps=4.68u w=2u l=4u
X545 vdd.t11 x1.level_shift_0[7].XM7.G0 x1.level_shift_0[7].XM2.D0 vdd.t0 sg13_hv_pmos ad=0.19p pd=1.38u as=0.34p ps=2.68u w=1u l=0.5u
X546 x2.diffa x1.vbg x2.outa1p.t5 vss.t27 sg13_hv_nmos ad=0.68p pd=4.68u as=0.68p ps=4.68u w=2u l=1u
X547 x1.ena_b_h x1.x1[0].XM7.D0 vss.t135 vss.t137 sg13_hv_nmos ad=0.19p pd=1.38u as=0.34p ps=2.68u w=1u l=0.5u
X548 x1.level_shift_0[3].out x1.level_shift_0[3].XM7.D0 vdd.t13 vdd.t0 sg13_hv_pmos ad=0.38p pd=2.38u as=0.38p ps=2.38u w=2u l=0.5u
X549 x2.diffb x1.vbg x2.outb1p.t0 vdd.t5 sg13_hv_pmos ad=1.36p pd=8.68u as=1.36p ps=8.68u w=4u l=1u
X550 x2.outa1p.t33 x2.outa1n.t51 vdd.t5 vdd.t5 sg13_hv_pmos ad=0.34p pd=2.68u as=0.34p ps=2.68u w=1u l=1u
X551 x1.xamp.out1p x1.xamp.vbn1 vss.t59 vss.t65 sg13_hv_nmos ad=0.34p pd=2.68u as=0.34p ps=2.68u w=1u l=1u
X552 x1.xamp.out1n x1.xamp.vbn1 vss.t59 vss.t77 sg13_hv_nmos ad=0.34p pd=2.68u as=0.34p ps=2.68u w=1u l=1u
X553 vdd.t50 vdd.t50 vdd.t50 vdd.t6 sg13_hv_pmos ad=1.36p pd=8.68u as=0 ps=0 w=4u l=1u
X554 vss.t145 x2.XMOP.G0_0 vbg.t4 vss.t144 sg13_hv_nmos ad=1.36p pd=8.68u as=1.36p ps=8.68u w=4u l=4u
X555 x1.x1[7].out x1.x1[7].XM7.D0 vss.t155 vss.t355 sg13_hv_nmos ad=0.19p pd=1.38u as=0.34p ps=2.68u w=1u l=0.5u
X556 vdd.t15 x1.level_shift_0[3].XM7.G0 x1.level_shift_0[3].XM2.D0 vdd.t0 sg13_hv_pmos ad=0.19p pd=1.38u as=0.34p ps=2.68u w=1u l=0.5u
X557 x2.outa1n.t7 x2.outa1n.t6 vdd.t99 vdd.t5 sg13_hv_pmos ad=0.34p pd=2.68u as=0.34p ps=2.68u w=1u l=1u
X558 vdd.t242 x1.x1[5].XM7.D0 x1.x1[5].out vdd.t0 sg13_hv_pmos ad=0.68p pd=4.68u as=0.38p ps=2.38u w=2u l=0.5u
X559 x1.xres.XR1[18].R1 x1.xres.XR1[16].R2 vss.t286 rhigh l=20u w=0.69u
X560 vdd.t50 vdd.t50 vdd.t50 vdd.t6 sg13_hv_pmos ad=1.36p pd=8.68u as=0 ps=0 w=4u l=1u
X561 x1.xamp.XM6.S0 x1.xamp.vbn2 x1.xamp.out1n vss.t180 sg13_hv_nmos ad=0.34p pd=2.68u as=0.34p ps=2.68u w=1u l=4u
X562 x1.x1[8].out x1.x1[8].XM7.D0 vdd.t209 vdd.t0 sg13_hv_pmos ad=0.38p pd=2.38u as=0.38p ps=2.38u w=2u l=0.5u
X563 vss.t59 vss.t59 vss.t59 vss.t75 sg13_hv_nmos ad=0.34p pd=2.68u as=0 ps=0 w=1u l=1u
X564 x1.x1[1].out x1.x1[1].XM7.D0 vss.t242 vss.t243 sg13_hv_nmos ad=0.19p pd=1.38u as=0.34p ps=2.68u w=1u l=0.5u
X565 x1.level_shift_0[1].out x1.level_shift_0[1].XM7.D0 vss.t259 vss.t261 sg13_hv_nmos ad=0.19p pd=1.38u as=0.34p ps=2.68u w=1u l=0.5u
X566 x2.outa1p.t23 x2.XM9.D0_0 x2.XMOP.G0_0 vdd.t5 sg13_hv_pmos ad=0.34p pd=2.68u as=0.34p ps=2.68u w=1u l=4u
X567 vss.t11 x1.x1[4].XM7.D0 x1.x1[4].out vss.t169 sg13_hv_nmos ad=0.34p pd=2.68u as=0.19p ps=1.38u w=1u l=0.5u
X568 x1.xamp.vbp1 x1.xamp.vbp2 x1.xamp.vbp2 vdd.t6 sg13_hv_pmos ad=0.68p pd=4.68u as=0.68p ps=4.68u w=2u l=4u
X569 x1.level_shift_0[1].XM7.D0 x1.level_shift_0[1].XM7.G0 vss.t259 vss.t261 sg13_hv_nmos ad=0.19p pd=1.38u as=0.34p ps=2.68u w=1u l=0.5u
X570 x2.diffa x2.vbn1 vss.t95 vss.t109 sg13_hv_nmos ad=0.34p pd=2.68u as=0.34p ps=2.68u w=1u l=1u
X571 vdd.t194 x1.level_shift_0[5].XM7.G0 x1.level_shift_0[5].XM7.D0 vdd.t0 sg13_hv_pmos ad=0.38p pd=2.38u as=0.68p ps=4.68u w=2u l=0.5u
X572 x1.xamp.XM1.S0 x1.xamp.vbp1 vdd.t6 vdd.t6 sg13_hv_pmos ad=0.34p pd=2.68u as=0.34p ps=2.68u w=1u l=1u
X573 x1.xamp.XM6.S0 x1.xamp.vbp2 x1.xamp.XM8.S1 vdd.t6 sg13_hv_pmos ad=0.68p pd=4.68u as=0.68p ps=4.68u w=2u l=4u
X574 x1.x1[3].XM7.D0 x1.x1[3].XM7.G0 vss.t7 vss.t265 sg13_hv_nmos ad=0.19p pd=1.38u as=0.34p ps=2.68u w=1u l=0.5u
X575 x1.x1[1].XM7.G0 x1.x1[1].XM2.D0 vdd.t106 vdd.t0 sg13_hv_pmos ad=0.34p pd=2.68u as=0.19p ps=1.38u w=1u l=0.5u
X576 x1.level_shift_0[6].XM7.G0 x1.level_shift_0[6].XM2.D0 vdd.t170 vdd.t0 sg13_hv_pmos ad=0.34p pd=2.68u as=0.19p ps=1.38u w=1u l=0.5u
X577 x1.xtr.top x1.xtr.XM0[15].S vss.t0 rppd l=3.4u w=1.41u
X578 x2.outb1n.t13 x2.vbn2 x2.XM9.D0_0 vss.t319 sg13_hv_nmos ad=0.68p pd=4.68u as=0.68p ps=4.68u w=2u l=4u
X579 vdd.t159 x1.x1[5].XM7.G0 x1.x1[5].XM7.D0 vdd.t0 sg13_hv_pmos ad=0.38p pd=2.38u as=0.68p ps=4.68u w=2u l=0.5u
X580 x2.outb1p.t24 x2.vbn1 vss.t120 vss.t404 sg13_hv_nmos ad=0.34p pd=2.68u as=0.34p ps=2.68u w=1u l=1u
X581 x1.XM1.G0 x1.xamp.vbn2 x1.xamp.out1p vss.t180 sg13_hv_nmos ad=0.34p pd=2.68u as=0.34p ps=2.68u w=1u l=4u
X582 x2.XM9.D0_0 x2.XM9.D0_0 x2.outa1n.t27 vdd.t5 sg13_hv_pmos ad=0.34p pd=2.68u as=0.34p ps=2.68u w=1u l=4u
X583 x1.xamp.XM1.S0 x1.xamp.vbp1 vdd.t50 vdd.t6 sg13_hv_pmos ad=0.34p pd=2.68u as=0.34p ps=2.68u w=1u l=1u
X584 x1.x1[2].XM2.D0 trim[13] vss.t242 vss.t289 sg13_hv_nmos ad=1.36p pd=8.68u as=0.76p ps=4.38u w=4u l=0.5u
X585 x2.vbn1 x2.vbn1 vss.t111 vss.t402 sg13_hv_nmos ad=0.34p pd=2.68u as=0.34p ps=2.68u w=1u l=1u
X586 x2.diffa vbg.t11 x2.outa1n.t44 vss.t96 sg13_hv_nmos ad=0.68p pd=4.68u as=0.68p ps=4.68u w=2u l=1u
X587 x1.x1[4].XM7.G0 x1.x1[4].XM2.D0 vdd.t115 vdd.t0 sg13_hv_pmos ad=0.34p pd=2.68u as=0.19p ps=1.38u w=1u l=0.5u
X588 x2.outb1n.t15 x2.vbn2 x2.XM9.D0_0 vss.t323 sg13_hv_nmos ad=0.68p pd=4.68u as=0.68p ps=4.68u w=2u l=4u
X589 vdd.t81 x2.XMOP.G0_0 vbg.t5 vdd.t5 sg13_hv_pmos ad=1.36p pd=8.68u as=1.36p ps=8.68u w=4u l=4u
X590 x2.XM9.D0_0 x2.XM9.D0_0 x2.outa1n.t28 vdd.t5 sg13_hv_pmos ad=0.34p pd=2.68u as=0.34p ps=2.68u w=1u l=4u
X591 x2.vbp1 x2.vbp1 vdd.t252 vdd.t5 sg13_hv_pmos ad=0.34p pd=2.68u as=0.34p ps=2.68u w=1u l=1u
X592 x1.XM1.G0 x1.xamp.vbp2 x1.xamp.XM8.D0 vdd.t6 sg13_hv_pmos ad=0.68p pd=4.68u as=0.68p ps=4.68u w=2u l=4u
X593 x1.level_shift_0[7].XM7.G0 x1.level_shift_0[7].XM2.D0 vdd.t11 vdd.t0 sg13_hv_pmos ad=0.34p pd=2.68u as=0.19p ps=1.38u w=1u l=0.5u
X594 vss.t242 x1.x1[1].in_n x1.x1[1].XM7.G0 vss.t270 sg13_hv_nmos ad=0.76p pd=4.38u as=1.36p ps=8.68u w=4u l=0.5u
X595 x2.diffa x1.vbg x2.outa1p.t7 vss.t29 sg13_hv_nmos ad=0.68p pd=4.68u as=0.68p ps=4.68u w=2u l=1u
X596 x1.level_shift_0[1].XM7.G0 x1.level_shift_0[1].XM2.D0 vdd.t98 vdd.t0 sg13_hv_pmos ad=0.34p pd=2.68u as=0.19p ps=1.38u w=1u l=0.5u
X597 x2.outa1p.t30 x2.XM9.D0_0 x2.XMOP.G0_0 vdd.t5 sg13_hv_pmos ad=0.34p pd=2.68u as=0.34p ps=2.68u w=1u l=4u
X598 x2.outb1p.t22 x2.vbn2 x2.XMOP.G0_0 vss.t322 sg13_hv_nmos ad=0.68p pd=4.68u as=0.68p ps=4.68u w=2u l=4u
X599 x1.level_shift_0[4].out x1.level_shift_0[4].XM7.D0 vdd.t10 vdd.t0 sg13_hv_pmos ad=0.38p pd=2.38u as=0.38p ps=2.38u w=2u l=0.5u
X600 x2.outb1n.t28 x2.vbn1 vss.t391 vss.t412 sg13_hv_nmos ad=0.34p pd=2.68u as=0.34p ps=2.68u w=1u l=1u
X601 x2.diffb x2.vbp1 vdd.t252 vdd.t5 sg13_hv_pmos ad=0.34p pd=2.68u as=0.34p ps=2.68u w=1u l=1u
X602 x1.level_shift_0[3].out x1.level_shift_0[3].XM7.D0 vss.t132 vss.t124 sg13_hv_nmos ad=0.19p pd=1.38u as=0.34p ps=2.68u w=1u l=0.5u
X603 x1.xtr.XM0[2].S x1.xtr.XM0[1].S vss.t0 rppd l=3.4u w=1.41u
X604 x2.outa1p.t16 x2.XM9.D0_0 x2.XMOP.G0_0 vdd.t5 sg13_hv_pmos ad=0.34p pd=2.68u as=0.34p ps=2.68u w=1u l=4u
X605 vdd.t109 x1.level_shift_0[6].XM7.D0 x1.level_shift_0[6].out vdd.t0 sg13_hv_pmos ad=0.68p pd=4.68u as=0.38p ps=2.38u w=2u l=0.5u
X606 x1.level_shift_0[3].XM7.D0 x1.level_shift_0[3].XM7.G0 vss.t132 vss.t131 sg13_hv_nmos ad=0.19p pd=1.38u as=0.34p ps=2.68u w=1u l=0.5u
X607 x2.vbn2 x2.vbp1 vdd.t121 vdd.t5 sg13_hv_pmos ad=0.34p pd=2.68u as=0.34p ps=2.68u w=1u l=1u
X608 ibias1_250n x1.ena_b_h x1.xamp.vbp2 vdd.t6 sg13_hv_pmos ad=0.68p pd=4.68u as=0.68p ps=4.68u w=2u l=4u
X609 x1.XM1.G0 x1.xamp.vbn2 x1.xamp.out1p vss.t181 sg13_hv_nmos ad=0.34p pd=2.68u as=0.34p ps=2.68u w=1u l=4u
X610 vss.t95 vss.t95 vss.t95 vss.t107 sg13_hv_nmos ad=0.34p pd=2.68u as=0 ps=0 w=1u l=1u
X611 x1.x1[8].out x1.x1[8].XM7.D0 vss.t18 vss.t296 sg13_hv_nmos ad=0.19p pd=1.38u as=0.34p ps=2.68u w=1u l=0.5u
X612 vdd.t1 x1.level_shift_0[4].XM7.G0 x1.level_shift_0[4].XM2.D0 vdd.t0 sg13_hv_pmos ad=0.19p pd=1.38u as=0.34p ps=2.68u w=1u l=0.5u
X613 x1.xamp.vbn2 x1.xamp.vbp1 vdd.t6 vdd.t6 sg13_hv_pmos ad=0.34p pd=2.68u as=0.34p ps=2.68u w=1u l=1u
X614 vdd.t212 x1.x1[6].XM7.D0 x1.x1[6].out vdd.t0 sg13_hv_pmos ad=0.68p pd=4.68u as=0.38p ps=2.38u w=2u l=0.5u
X615 x1.xamp.out1p x1.xamp.vbn1 vss.t59 vss.t65 sg13_hv_nmos ad=0.34p pd=2.68u as=0.34p ps=2.68u w=1u l=1u
X616 x1.XM1.G0 x1.xamp.vbp2 x1.xamp.XM8.D0 vdd.t6 sg13_hv_pmos ad=0.68p pd=4.68u as=0.68p ps=4.68u w=2u l=4u
X617 vdd.t89 x1.x1[6].XM7.G0 x1.x1[6].XM2.D0 vdd.t0 sg13_hv_pmos ad=0.19p pd=1.38u as=0.34p ps=2.68u w=1u l=0.5u
X618 x1.xamp.out1n x1.xamp.vbn1 vss.t59 vss.t77 sg13_hv_nmos ad=0.34p pd=2.68u as=0.34p ps=2.68u w=1u l=1u
X619 x1.xamp.vbp1 x1.xamp.vbp1 vdd.t6 vdd.t6 sg13_hv_pmos ad=0.34p pd=2.68u as=0.34p ps=2.68u w=1u l=1u
X620 vss.t155 x1.x1[6].XM7.D0 x1.x1[6].out vss.t154 sg13_hv_nmos ad=0.34p pd=2.68u as=0.19p ps=1.38u w=1u l=0.5u
X621 x1.level_shift_0[4].out x1.level_shift_0[4].XM7.D0 vss.t125 vss.t124 sg13_hv_nmos ad=0.19p pd=1.38u as=0.34p ps=2.68u w=1u l=0.5u
X622 x1.level_shift_0[3].out x1.level_shift_0[3].XM7.D0 vdd.t14 vdd.t0 sg13_hv_pmos ad=0.38p pd=2.38u as=0.38p ps=2.38u w=2u l=0.5u
X623 vss.t155 trim[3] x1.x1[7].XM2.D0 vss.t335 sg13_hv_nmos ad=0.76p pd=4.38u as=1.36p ps=8.68u w=4u l=0.5u
X624 x1.vs1 x1.vbg vss.t21 vss.t20 sg13_hv_nmos ad=0.34p pd=2.68u as=0.34p ps=2.68u w=1u l=1u
X625 x1.x1[2].out x1.x1[2].XM7.D0 vdd.t133 vdd.t0 sg13_hv_pmos ad=0.38p pd=2.38u as=0.38p ps=2.38u w=2u l=0.5u
X626 x1.level_shift_0[4].XM7.D0 x1.level_shift_0[4].XM7.G0 vss.t125 vss.t131 sg13_hv_nmos ad=0.19p pd=1.38u as=0.34p ps=2.68u w=1u l=0.5u
X627 vss.t242 x1.x1[1].XM7.G0 x1.x1[1].XM7.D0 vss.t241 sg13_hv_nmos ad=0.34p pd=2.68u as=0.19p ps=1.38u w=1u l=0.5u
X628 x1.x1[0].XM7.G0 ena vss.t135 vss.t452 sg13_hv_nmos ad=1.36p pd=8.68u as=0.76p ps=4.38u w=4u l=0.5u
X629 vss.t59 vss.t59 vss.t59 vss.t75 sg13_hv_nmos ad=0.34p pd=2.68u as=0 ps=0 w=1u l=1u
X630 vdd.t83 x2.XMOP.G0_0 vbg.t3 vdd.t5 sg13_hv_pmos ad=1.36p pd=8.68u as=1.36p ps=8.68u w=4u l=4u
X631 x1.xamp.out1p x1.xres.c x1.xamp.XM1.S0 vdd.t6 sg13_hv_pmos ad=1.36p pd=8.68u as=1.36p ps=8.68u w=4u l=1u
X632 x1.XM1.G0 x1.xamp.vbn2 x1.xamp.out1p vss.t180 sg13_hv_nmos ad=0.34p pd=2.68u as=0.34p ps=2.68u w=1u l=4u
X633 x2.outa1n.t19 x2.outa1n.t18 vdd.t5 vdd.t5 sg13_hv_pmos ad=0.34p pd=2.68u as=0.34p ps=2.68u w=1u l=1u
X634 x1.x1[3].out x1.x1[3].XM7.D0 vss.t7 vss.t265 sg13_hv_nmos ad=0.19p pd=1.38u as=0.34p ps=2.68u w=1u l=0.5u
X635 x1.level_shift_0[1].XM2.D0 trim[12] vss.t14 vss.t267 sg13_hv_nmos ad=1.36p pd=8.68u as=0.76p ps=4.38u w=4u l=0.5u
X636 vss.t259 x1.level_shift_0[1].XM7.D0 x1.level_shift_0[1].out vss.t258 sg13_hv_nmos ad=0.34p pd=2.68u as=0.19p ps=1.38u w=1u l=0.5u
X637 vdd.t171 x1.level_shift_0[6].XM7.G0 x1.level_shift_0[6].XM2.D0 vdd.t0 sg13_hv_pmos ad=0.19p pd=1.38u as=0.34p ps=2.68u w=1u l=0.5u
X638 x2.outb1n.t36 x2.vbn1 vss.t120 vss.t405 sg13_hv_nmos ad=0.34p pd=2.68u as=0.34p ps=2.68u w=1u l=1u
X639 x1.xamp.XM1.S0 x1.xamp.vbp1 vdd.t6 vdd.t6 sg13_hv_pmos ad=0.34p pd=2.68u as=0.34p ps=2.68u w=1u l=1u
X640 x1.x1[3].XM2.D0 trim[11] vss.t7 vss.t6 sg13_hv_nmos ad=1.36p pd=8.68u as=0.76p ps=4.38u w=4u l=0.5u
X641 x1.xamp.out1p x1.xres.c x1.xamp.XM1.S0 vdd.t6 sg13_hv_pmos ad=1.36p pd=8.68u as=1.36p ps=8.68u w=4u l=1u
X642 vdd.t154 x1.x1[1].XM7.G0 x1.x1[1].XM7.D0 vdd.t0 sg13_hv_pmos ad=0.38p pd=2.38u as=0.68p ps=4.68u w=2u l=0.5u
X643 vss.t18 x1.x1[7].XM7.D0 x1.x1[7].out vss.t354 sg13_hv_nmos ad=0.34p pd=2.68u as=0.19p ps=1.38u w=1u l=0.5u
X644 x2.diffa vbg.t9 x2.outa1n.t46 vss.t352 sg13_hv_nmos ad=0.68p pd=4.68u as=0.68p ps=4.68u w=2u l=1u
X645 vss.t58 x1.level_shift_0[7].XM7.D0 x1.level_shift_0[7].out vss.t124 sg13_hv_nmos ad=0.34p pd=2.68u as=0.19p ps=1.38u w=1u l=0.5u
X646 x1.xres.XR1[6].R1 x1.xres.XR1[8].R2 vss.t384 rhigh l=20u w=0.69u
X647 x2.outb1n.t9 x2.vbn2 x2.XM9.D0_0 vss.t320 sg13_hv_nmos ad=0.68p pd=4.68u as=0.68p ps=4.68u w=2u l=4u
X648 x2.outb1p.t37 x2.vbn1 vss.t120 vss.t389 sg13_hv_nmos ad=0.34p pd=2.68u as=0.34p ps=2.68u w=1u l=1u
X649 vss.t58 x1.level_shift_0[7].XM7.G0 x1.level_shift_0[7].XM7.D0 vss.t131 sg13_hv_nmos ad=0.34p pd=2.68u as=0.19p ps=1.38u w=1u l=0.5u
X650 vss.t147 x2.XMOP.G0_0 vbg.t0 vss.t146 sg13_hv_nmos ad=1.36p pd=8.68u as=1.36p ps=8.68u w=4u l=4u
X651 x1.XM1.G0 x1.xamp.vbp2 x1.xamp.XM8.D0 vdd.t6 sg13_hv_pmos ad=0.68p pd=4.68u as=0.68p ps=4.68u w=2u l=4u
X652 x1.x1[5].XM7.G0 x1.x1[5].XM2.D0 vdd.t161 vdd.t0 sg13_hv_pmos ad=0.34p pd=2.68u as=0.19p ps=1.38u w=1u l=0.5u
X653 x2.diffa x1.vbg x2.outa1p.t6 vss.t28 sg13_hv_nmos ad=0.68p pd=4.68u as=0.68p ps=4.68u w=2u l=1u
X654 vss.t59 vss.t59 vss.t59 vss.t65 sg13_hv_nmos ad=0.34p pd=2.68u as=0 ps=0 w=1u l=1u
X655 x2.outb1p.t8 x2.vbn2 x2.XMOP.G0_0 vss.t297 sg13_hv_nmos ad=0.68p pd=4.68u as=0.68p ps=4.68u w=2u l=4u
X656 x2.diffb x1.vbg x2.outb1p.t7 vdd.t5 sg13_hv_pmos ad=1.36p pd=8.68u as=1.36p ps=8.68u w=4u l=1u
X657 vdd.t50 vdd.t50 vdd.t50 vdd.t6 sg13_hv_pmos ad=0.34p pd=2.68u as=0 ps=0 w=1u l=1u
X658 vss.t115 vss.t111 vss.t111 vss.t113 sg13_hv_nmos ad=0.34p pd=2.68u as=0 ps=0 w=1u l=1u
X659 vss.t95 vss.t95 vss.t95 vss.t99 sg13_hv_nmos ad=0.34p pd=2.68u as=0 ps=0 w=1u l=1u
X660 x2.XMB4.S0 x1.ena_b_h ibias2_1u vdd.t5 sg13_hv_pmos ad=0.34p pd=2.68u as=0.34p ps=2.68u w=1u l=4u
X661 vss.t171 x1.x1[4].in_n x1.x1[4].XM7.G0 vss.t294 sg13_hv_nmos ad=0.76p pd=4.38u as=1.36p ps=8.68u w=4u l=0.5u
X662 x1.xres.XR1[17].R1 x1.xres.c vss.t255 rhigh l=20u w=0.69u
X663 vdd.t221 x1.x1[1].XM7.D0 x1.x1[1].out vdd.t0 sg13_hv_pmos ad=0.68p pd=4.68u as=0.38p ps=2.38u w=2u l=0.5u
X664 x1.x1[6].XM2.D0 trim[5] vss.t11 vss.t339 sg13_hv_nmos ad=1.36p pd=8.68u as=0.76p ps=4.38u w=4u l=0.5u
X665 vdd.t50 vdd.t50 vdd.t50 vdd.t6 sg13_hv_pmos ad=1.36p pd=8.68u as=0 ps=0 w=4u l=1u
X666 x2.XM9.D0_0 x2.XM9.D0_0 x2.outa1n.t30 vdd.t5 sg13_hv_pmos ad=0.34p pd=2.68u as=0.34p ps=2.68u w=1u l=4u
X667 x2.diffb x1.vbg x2.outb1p.t1 vdd.t5 sg13_hv_pmos ad=1.36p pd=8.68u as=1.36p ps=8.68u w=4u l=1u
X668 x1.xamp.out1p x1.xamp.vbn1 vss.t59 vss.t65 sg13_hv_nmos ad=0.34p pd=2.68u as=0.34p ps=2.68u w=1u l=1u
X669 x2.outa1n.t3 x2.outa1n.t2 vdd.t112 vdd.t5 sg13_hv_pmos ad=0.34p pd=2.68u as=0.34p ps=2.68u w=1u l=1u
X670 vdd.t107 x1.x1[1].XM7.G0 x1.x1[1].XM2.D0 vdd.t0 sg13_hv_pmos ad=0.19p pd=1.38u as=0.34p ps=2.68u w=1u l=0.5u
X671 x1.xamp.out1n x1.xamp.vbn1 vss.t59 vss.t77 sg13_hv_nmos ad=0.34p pd=2.68u as=0.34p ps=2.68u w=1u l=1u
X672 x1.xamp.out1n x1.xres.d x1.xamp.XM1.S0 vdd.t6 sg13_hv_pmos ad=1.36p pd=8.68u as=1.36p ps=8.68u w=4u l=1u
X673 x1.x1[3].XM7.G0 x1.x1[3].XM2.D0 vdd.t126 vdd.t0 sg13_hv_pmos ad=0.34p pd=2.68u as=0.19p ps=1.38u w=1u l=0.5u
X674 x1.xamp.vbn1 x1.xamp.vbn2 x1.xamp.vbn2 vss.t179 sg13_hv_nmos ad=0.34p pd=2.68u as=0.34p ps=2.68u w=1u l=4u
X675 vdd.t236 x1.x1[7].XM7.G0 x1.x1[7].XM7.D0 vdd.t0 sg13_hv_pmos ad=0.38p pd=2.38u as=0.68p ps=4.68u w=2u l=0.5u
X676 vss.t299 x2.vbn2 vss.t298 vss.t297 sg13_hv_nmos ad=0.68p pd=4.68u as=0 ps=0 w=2u l=4u
X677 x1.XM1.G0 x1.xamp.vbp2 x1.xamp.XM8.D0 vdd.t6 sg13_hv_pmos ad=0.68p pd=4.68u as=0.68p ps=4.68u w=2u l=4u
X678 x1.xamp.XM6.S0 x1.xamp.vbp2 x1.xamp.XM8.S1 vdd.t6 sg13_hv_pmos ad=0.68p pd=4.68u as=0.68p ps=4.68u w=2u l=4u
X679 x1.x1[6].XM7.D0 x1.x1[6].XM7.G0 vss.t122 vss.t156 sg13_hv_nmos ad=0.19p pd=1.38u as=0.34p ps=2.68u w=1u l=0.5u
X680 x2.outb1p.t20 x2.vbn2 x2.XMOP.G0_0 vss.t318 sg13_hv_nmos ad=0.68p pd=4.68u as=0.68p ps=4.68u w=2u l=4u
X681 vdd.t26 x1.xamp.XM6.S0 x1.xamp.XM8.S1 vdd.t6 sg13_hv_pmos ad=0.68p pd=4.68u as=0.68p ps=4.68u w=2u l=4u
X682 x2.outb1n.t41 x2.vbn1 vss.t95 vss.t387 sg13_hv_nmos ad=0.34p pd=2.68u as=0.34p ps=2.68u w=1u l=1u
X683 x2.diffb x1.vbg x2.outb1p.t4 vdd.t5 sg13_hv_pmos ad=1.36p pd=8.68u as=1.36p ps=8.68u w=4u l=1u
X684 x1.level_shift_0[5].XM7.G0 x1.level_shift_0[5].XM2.D0 vdd.t4 vdd.t0 sg13_hv_pmos ad=0.34p pd=2.68u as=0.19p ps=1.38u w=1u l=0.5u
X685 vss.t59 vss.t59 vss.t59 vss.t77 sg13_hv_nmos ad=0.34p pd=2.68u as=0 ps=0 w=1u l=1u
X686 x1.x1[7].XM7.G0 x1.x1[7].in_n vss.t155 vss.t374 sg13_hv_nmos ad=1.36p pd=8.68u as=0.76p ps=4.38u w=4u l=0.5u
X687 x2.vbn2 x2.vbn2 x2.vbn1 vss.t316 sg13_hv_nmos ad=0.68p pd=4.68u as=0.68p ps=4.68u w=2u l=4u
X688 x2.outa1p.t18 x2.XM9.D0_0 x2.XMOP.G0_0 vdd.t5 sg13_hv_pmos ad=0.34p pd=2.68u as=0.34p ps=2.68u w=1u l=4u
X689 vss.t167 trim[2] x1.level_shift_0[6].XM2.D0 vss.t239 sg13_hv_nmos ad=0.76p pd=4.38u as=1.36p ps=8.68u w=4u l=0.5u
X690 x2.diffa x2.vbn1 vss.t95 vss.t27 sg13_hv_nmos ad=0.34p pd=2.68u as=0.34p ps=2.68u w=1u l=1u
X691 x1.x1[5].XM2.D0 trim[7] vss.t11 vss.t10 sg13_hv_nmos ad=1.36p pd=8.68u as=0.76p ps=4.38u w=4u l=0.5u
X692 vdd.t180 x1.x1[3].XM7.G0 x1.x1[3].XM7.D0 vdd.t0 sg13_hv_pmos ad=0.38p pd=2.38u as=0.68p ps=4.68u w=2u l=0.5u
X693 x1.level_shift_0[6].out x1.level_shift_0[6].XM7.D0 vss.t167 vss.t126 sg13_hv_nmos ad=0.19p pd=1.38u as=0.34p ps=2.68u w=1u l=0.5u
X694 ibias1_250n x1.ena_b_h x1.xamp.vbp2 vdd.t6 sg13_hv_pmos ad=0.68p pd=4.68u as=0.68p ps=4.68u w=2u l=4u
X695 vss.t18 trim[1] x1.x1[8].XM2.D0 vss.t143 sg13_hv_nmos ad=0.76p pd=4.38u as=1.36p ps=8.68u w=4u l=0.5u
X696 vdd.t138 x1.x1[2].XM7.G0 x1.x1[2].XM2.D0 vdd.t0 sg13_hv_pmos ad=0.19p pd=1.38u as=0.34p ps=2.68u w=1u l=0.5u
X697 x1.level_shift_0[1].out x1.level_shift_0[1].XM7.D0 vdd.t174 vdd.t0 sg13_hv_pmos ad=0.38p pd=2.38u as=0.38p ps=2.38u w=2u l=0.5u
X698 x1.xtr.top x1.xres.d vss.t184 rhigh l=20u w=0.69u
X699 x1.xres.XR1[5].R1 x1.xres.XR1[7].R2 vss.t141 rhigh l=20u w=0.69u
X700 x1.xamp.XM6.S0 x1.xamp.vbn2 x1.xamp.out1n vss.t181 sg13_hv_nmos ad=0.34p pd=2.68u as=0.34p ps=2.68u w=1u l=4u
X701 x1.XQ2_7.E x1.level_shift_0[6].out x1.xtr.XM0[3].S vss.t56 sg13_hv_nmos ad=0.68p pd=4.68u as=0.68p ps=4.68u w=2u l=0.5u
X702 x2.diffb x2.vbp1 vdd.t252 vdd.t5 sg13_hv_pmos ad=0.34p pd=2.68u as=0.34p ps=2.68u w=1u l=1u
X703 x1.xamp.XM6.S0 x1.xamp.vbp2 x1.xamp.XM8.S1 vdd.t6 sg13_hv_pmos ad=0.68p pd=4.68u as=0.68p ps=4.68u w=2u l=4u
X704 vdd.t210 x1.x1[8].XM7.G0 x1.x1[8].XM7.D0 vdd.t0 sg13_hv_pmos ad=0.38p pd=2.38u as=0.68p ps=4.68u w=2u l=0.5u
X705 vss.t242 x1.x1[1].XM7.D0 x1.x1[1].out vss.t241 sg13_hv_nmos ad=0.34p pd=2.68u as=0.19p ps=1.38u w=1u l=0.5u
X706 vss.t14 x1.level_shift_0[0].in_n x1.level_shift_0[0].XM7.G0 vss.t292 sg13_hv_nmos ad=0.76p pd=4.38u as=1.36p ps=8.68u w=4u l=0.5u
X707 vss.t122 x1.x1[6].in_n x1.x1[6].XM7.G0 vss.t123 sg13_hv_nmos ad=0.76p pd=4.38u as=1.36p ps=8.68u w=4u l=0.5u
X708 x2.outb1p.t29 x2.vbn1 vss.t95 vss.t413 sg13_hv_nmos ad=0.34p pd=2.68u as=0.34p ps=2.68u w=1u l=1u
X709 x2.outa1p.t25 x2.XM9.D0_0 x2.XMOP.G0_0 vdd.t5 sg13_hv_pmos ad=0.34p pd=2.68u as=0.34p ps=2.68u w=1u l=4u
X710 x1.XQ2_7.E x1.x1[7].out x1.xtr.XM0[4].S vss.t56 sg13_hv_nmos ad=0.68p pd=4.68u as=0.68p ps=4.68u w=2u l=0.5u
X711 x1.level_shift_0[0].out x1.level_shift_0[0].XM7.D0 vss.t14 vss.t223 sg13_hv_nmos ad=0.19p pd=1.38u as=0.34p ps=2.68u w=1u l=0.5u
X712 vss.t132 x1.level_shift_0[3].XM7.D0 x1.level_shift_0[3].out vss.t124 sg13_hv_nmos ad=0.34p pd=2.68u as=0.19p ps=1.38u w=1u l=0.5u
X713 x1.level_shift_0[2].XM2.D0 trim[10] vss.t259 vss.t346 sg13_hv_nmos ad=1.36p pd=8.68u as=0.76p ps=4.38u w=4u l=0.5u
X714 x1.xamp.out1p x1.xres.c x1.xamp.XM1.S0 vdd.t6 sg13_hv_pmos ad=1.36p pd=8.68u as=1.36p ps=8.68u w=4u l=1u
X715 vdd.t50 vdd.t50 vdd.t50 vdd.t6 sg13_hv_pmos ad=0.34p pd=2.68u as=0 ps=0 w=1u l=1u
X716 vss.t132 x1.level_shift_0[3].XM7.G0 x1.level_shift_0[3].XM7.D0 vss.t131 sg13_hv_nmos ad=0.34p pd=2.68u as=0.19p ps=1.38u w=1u l=0.5u
X717 x2.outb1n.t14 x2.vbn2 x2.XM9.D0_0 vss.t321 sg13_hv_nmos ad=0.68p pd=4.68u as=0.68p ps=4.68u w=2u l=4u
X718 x2.outb1p.t46 x2.vbn1 vss.t95 vss.t422 sg13_hv_nmos ad=0.34p pd=2.68u as=0.34p ps=2.68u w=1u l=1u
X719 x1.XQ2_7.E x1.x1[6].out x1.xtr.XM0[6].S vss.t56 sg13_hv_nmos ad=0.68p pd=4.68u as=0.68p ps=4.68u w=2u l=0.5u
X720 vdd.t147 x1.level_shift_0[0].XM7.G0 x1.level_shift_0[0].XM7.D0 vdd.t0 sg13_hv_pmos ad=0.38p pd=2.38u as=0.68p ps=4.68u w=2u l=0.5u
X721 x1.x1[6].out x1.x1[6].XM7.D0 vdd.t91 vdd.t0 sg13_hv_pmos ad=0.38p pd=2.38u as=0.38p ps=2.38u w=2u l=0.5u
X722 vss.t11 x1.x1[5].XM7.G0 x1.x1[5].XM7.D0 vss.t247 sg13_hv_nmos ad=0.34p pd=2.68u as=0.19p ps=1.38u w=1u l=0.5u
X723 x1.xres.XR1[10].R1 x1.xres.XR1[12].R2 vss.t233 rhigh l=20u w=0.69u
X724 x2.outb1n.t46 x2.vbn1 vss.t95 vss.t388 sg13_hv_nmos ad=0.34p pd=2.68u as=0.34p ps=2.68u w=1u l=1u
X725 x1.XQ2_7.E x1.level_shift_0[4].out x1.xtr.XM0[7].S vss.t56 sg13_hv_nmos ad=0.68p pd=4.68u as=0.68p ps=4.68u w=2u l=0.5u
X726 x1.vbg x1.XM1.G0 vdd.t103 vdd.t101 sg13_hv_pmos ad=1.36p pd=8.68u as=1.36p ps=8.68u w=4u l=1u
X727 x2.outb1n.t3 x2.vbn2 x2.XM9.D0_0 vss.t304 sg13_hv_nmos ad=0.68p pd=4.68u as=0.68p ps=4.68u w=2u l=4u
X728 x2.outa1p.t15 x2.outa1n.t48 vdd.t5 vdd.t5 sg13_hv_pmos ad=0.34p pd=2.68u as=0.34p ps=2.68u w=1u l=1u
X729 ibias1_250n x1.ena_b_h x1.xamp.vbp2 vdd.t6 sg13_hv_pmos ad=0.68p pd=4.68u as=0.68p ps=4.68u w=2u l=4u
X730 vdd.t239 x1.x1[8].XM7.D0 x1.x1[8].out vdd.t0 sg13_hv_pmos ad=0.68p pd=4.68u as=0.38p ps=2.38u w=2u l=0.5u
X731 x2.diffa vbg.t14 x2.outa1n.t41 vss.t349 sg13_hv_nmos ad=0.68p pd=4.68u as=0.68p ps=4.68u w=2u l=1u
X732 x1.XM1.S0 x1.XM1.G0 vdd.t102 vdd.t101 sg13_hv_pmos ad=1.36p pd=8.68u as=1.36p ps=8.68u w=4u l=1u
X733 vdd.t211 x1.x1[8].XM7.G0 x1.x1[8].XM2.D0 vdd.t0 sg13_hv_pmos ad=0.19p pd=1.38u as=0.34p ps=2.68u w=1u l=0.5u
X734 x1.level_shift_0[5].XM2.D0 trim[4] vss.t125 vss.t239 sg13_hv_nmos ad=1.36p pd=8.68u as=0.76p ps=4.38u w=4u l=0.5u
X735 x2.outb1n.t39 x2.vbn1 vss.t391 vss.t409 sg13_hv_nmos ad=0.34p pd=2.68u as=0.34p ps=2.68u w=1u l=1u
X736 x1.XQ2_7.E x1.x1[4].out x1.xtr.XM0[10].S vss.t56 sg13_hv_nmos ad=0.68p pd=4.68u as=0.68p ps=4.68u w=2u l=0.5u
X737 vdd.t50 vdd.t50 vdd.t50 vdd.t6 sg13_hv_pmos ad=1.36p pd=8.68u as=0 ps=0 w=4u l=1u
X738 vdd.t145 x1.level_shift_0[0].XM7.D0 x1.level_shift_0[0].out vdd.t0 sg13_hv_pmos ad=0.68p pd=4.68u as=0.38p ps=2.38u w=2u l=0.5u
X739 x1.x1[7].XM2.D0 trim[3] vss.t155 vss.t334 sg13_hv_nmos ad=1.36p pd=8.68u as=0.76p ps=4.38u w=4u l=0.5u
X740 x2.outb1n.t33 x2.vbn1 vss.t95 vss.t420 sg13_hv_nmos ad=0.34p pd=2.68u as=0.34p ps=2.68u w=1u l=1u
X741 x2.outb1p.t40 x2.vbn1 vss.t391 vss.t390 sg13_hv_nmos ad=0.34p pd=2.68u as=0.34p ps=2.68u w=1u l=1u
X742 vss.t50 vss.t49 x1.XQ2_7.E pnpMPA a=1.4p p=5.4u
**devattr d=249408261,157565
X743 vss.t59 vss.t59 vss.t59 vss.t65 sg13_hv_nmos ad=0.34p pd=2.68u as=0 ps=0 w=1u l=1u
X744 vdd.t50 vdd.t50 vdd.t50 vdd.t6 sg13_hv_pmos ad=1.36p pd=8.68u as=0 ps=0 w=4u l=1u
X745 x1.x1[7].out x1.x1[7].XM7.D0 vdd.t236 vdd.t0 sg13_hv_pmos ad=0.38p pd=2.38u as=0.38p ps=2.38u w=2u l=0.5u
X746 vdd.t116 x1.x1[4].XM7.G0 x1.x1[4].XM2.D0 vdd.t0 sg13_hv_pmos ad=0.19p pd=1.38u as=0.34p ps=2.68u w=1u l=0.5u
X747 x2.diffa x2.vbn1 vss.t95 vss.t96 sg13_hv_nmos ad=0.34p pd=2.68u as=0.34p ps=2.68u w=1u l=1u
X748 x1.xamp.vbp1 x1.xamp.vbp1 vdd.t6 vdd.t6 sg13_hv_pmos ad=0.34p pd=2.68u as=0.34p ps=2.68u w=1u l=1u
X749 vdd.t110 x1.level_shift_0[6].XM7.G0 x1.level_shift_0[6].XM7.D0 vdd.t0 sg13_hv_pmos ad=0.38p pd=2.38u as=0.68p ps=4.68u w=2u l=0.5u
X750 x1.vs2 x1.vs2 vdd.t139 vdd.t101 sg13_hv_pmos ad=0.34p pd=2.68u as=0.34p ps=2.68u w=1u l=1u
X751 x2.outa1p.t32 x2.outa1n.t56 vdd.t99 vdd.t5 sg13_hv_pmos ad=0.34p pd=2.68u as=0.34p ps=2.68u w=1u l=1u
X752 x1.xres.XR1[2].R1 x1.vbg vss.t164 rhigh l=20u w=0.69u
X753 x1.x1[6].out x1.x1[6].XM7.D0 vss.t122 vss.t156 sg13_hv_nmos ad=0.19p pd=1.38u as=0.34p ps=2.68u w=1u l=0.5u
X754 x1.level_shift_0[4].XM2.D0 trim[6] vss.t132 vss.t239 sg13_hv_nmos ad=1.36p pd=8.68u as=0.76p ps=4.38u w=4u l=0.5u
X755 x2.outb1p.t27 x2.vbn1 vss.t391 vss.t411 sg13_hv_nmos ad=0.34p pd=2.68u as=0.34p ps=2.68u w=1u l=1u
X756 x2.outa1n.t9 x2.outa1n.t8 vdd.t99 vdd.t5 sg13_hv_pmos ad=0.34p pd=2.68u as=0.34p ps=2.68u w=1u l=1u
X757 x1.x1[1].out x1.x1[1].XM7.D0 vdd.t153 vdd.t0 sg13_hv_pmos ad=0.38p pd=2.38u as=0.38p ps=2.38u w=2u l=0.5u
X758 vss.t58 trim[0] x1.level_shift_0[7].XM2.D0 vss.t239 sg13_hv_nmos ad=0.76p pd=4.38u as=1.36p ps=8.68u w=4u l=0.5u
X759 x2.vbp1 x2.XMB4.S0 x2.XMB4.S0 vdd.t5 sg13_hv_pmos ad=0.34p pd=2.68u as=0.34p ps=2.68u w=1u l=4u
X760 x1.xamp.XM6.S0 x1.xamp.vbn2 x1.xamp.out1n vss.t181 sg13_hv_nmos ad=0.34p pd=2.68u as=0.34p ps=2.68u w=1u l=4u
X761 x1.level_shift_0[7].out x1.level_shift_0[7].XM7.D0 vss.t58 vss.t126 sg13_hv_nmos ad=0.19p pd=1.38u as=0.34p ps=2.68u w=1u l=0.5u
X762 x2.outb1p.t17 x2.vbn2 x2.XMOP.G0_0 vss.t319 sg13_hv_nmos ad=0.68p pd=4.68u as=0.68p ps=4.68u w=2u l=4u
X763 x1.x1[7].XM7.G0 x1.x1[7].XM2.D0 vdd.t158 vdd.t0 sg13_hv_pmos ad=0.34p pd=2.68u as=0.19p ps=1.38u w=1u l=0.5u
X764 x1.xamp.vbn1 x1.xamp.vbn2 x1.xamp.vbn2 vss.t179 sg13_hv_nmos ad=0.34p pd=2.68u as=0.34p ps=2.68u w=1u l=4u
X765 vss.t59 vss.t59 vss.t59 vss.t77 sg13_hv_nmos ad=0.34p pd=2.68u as=0 ps=0 w=1u l=1u
X766 x2.outb1n.t44 x2.vbn1 vss.t95 vss.t419 sg13_hv_nmos ad=0.34p pd=2.68u as=0.34p ps=2.68u w=1u l=1u
X767 x1.xamp.XM6.S0 x1.xamp.vbp2 x1.xamp.XM8.S1 vdd.t6 sg13_hv_pmos ad=0.68p pd=4.68u as=0.68p ps=4.68u w=2u l=4u
X768 vdd.t25 x1.xamp.XM6.S0 x1.xamp.XM8.D0 vdd.t6 sg13_hv_pmos ad=0.68p pd=4.68u as=0.68p ps=4.68u w=2u l=4u
X769 x1.XQ2_7.E x1.x1[5].out x1.xtr.XM0[8].S vss.t56 sg13_hv_nmos ad=0.68p pd=4.68u as=0.68p ps=4.68u w=2u l=0.5u
X770 x1.xres.XR1[9].R1 x1.xres.XR1[7].R2 vss.t2 rhigh l=20u w=0.69u
X771 x1.xamp.out1n x1.xres.d x1.xamp.XM1.S0 vdd.t6 sg13_hv_pmos ad=1.36p pd=8.68u as=1.36p ps=8.68u w=4u l=1u
X772 vdd.t87 x1.level_shift_0[7].XM7.G0 x1.level_shift_0[7].XM7.D0 vdd.t0 sg13_hv_pmos ad=0.38p pd=2.38u as=0.68p ps=4.68u w=2u l=0.5u
X773 vss.t7 x1.x1[3].XM7.D0 x1.x1[3].out vss.t263 sg13_hv_nmos ad=0.34p pd=2.68u as=0.19p ps=1.38u w=1u l=0.5u
X774 x2.outb1p.t45 x2.vbn1 vss.t95 vss.t421 sg13_hv_nmos ad=0.34p pd=2.68u as=0.34p ps=2.68u w=1u l=1u
X775 vss.t132 x1.level_shift_0[3].in_n x1.level_shift_0[3].XM7.G0 vss.t172 sg13_hv_nmos ad=0.76p pd=4.38u as=1.36p ps=8.68u w=4u l=0.5u
X776 vdd.t218 x1.level_shift_0[2].XM7.G0 x1.level_shift_0[2].XM2.D0 vdd.t0 sg13_hv_pmos ad=0.19p pd=1.38u as=0.34p ps=2.68u w=1u l=0.5u
X777 vss.t167 x1.level_shift_0[5].XM7.D0 x1.level_shift_0[5].out vss.t126 sg13_hv_nmos ad=0.34p pd=2.68u as=0.19p ps=1.38u w=1u l=0.5u
X778 x2.diffa x1.vbg x2.outa1p.t0 vss.t22 sg13_hv_nmos ad=0.68p pd=4.68u as=0.68p ps=4.68u w=2u l=1u
X779 vdd.t164 x1.x1[4].XM7.D0 x1.x1[4].out vdd.t0 sg13_hv_pmos ad=0.68p pd=4.68u as=0.38p ps=2.38u w=2u l=0.5u
X780 x1.XQ2_7.E x1.level_shift_0[2].out x1.xtr.XM0[11].S vss.t56 sg13_hv_nmos ad=0.68p pd=4.68u as=0.68p ps=4.68u w=2u l=0.5u
X781 x2.outb1p.t19 x2.vbn2 x2.XMOP.G0_0 vss.t323 sg13_hv_nmos ad=0.68p pd=4.68u as=0.68p ps=4.68u w=2u l=4u
X782 x2.outa1p.t22 x2.XM9.D0_0 x2.XMOP.G0_0 vdd.t5 sg13_hv_pmos ad=0.34p pd=2.68u as=0.34p ps=2.68u w=1u l=4u
X783 x1.level_shift_0[5].out x1.level_shift_0[5].XM7.D0 vdd.t193 vdd.t0 sg13_hv_pmos ad=0.38p pd=2.38u as=0.38p ps=2.38u w=2u l=0.5u
X784 vss.t34 vss.t38 x1.XQ2_7.E pnpMPA a=1.4p p=5.4u
**devattr d=249408261,157565
X785 x1.XM1.G0 x1.xamp.vbn2 x1.xamp.out1p vss.t181 sg13_hv_nmos ad=0.34p pd=2.68u as=0.34p ps=2.68u w=1u l=4u
X786 x2.outb1n.t31 x2.vbn1 vss.t95 vss.t417 sg13_hv_nmos ad=0.34p pd=2.68u as=0.34p ps=2.68u w=1u l=1u
X787 x1.x1[8].XM7.G0 x1.x1[8].XM2.D0 vdd.t211 vdd.t0 sg13_hv_pmos ad=0.34p pd=2.68u as=0.19p ps=1.38u w=1u l=0.5u
X788 x2.diffa vbg.t12 x2.outa1n.t43 vss.t351 sg13_hv_nmos ad=0.68p pd=4.68u as=0.68p ps=4.68u w=2u l=1u
X789 x2.outa1p.t27 x2.XM9.D0_0 x2.XMOP.G0_0 vdd.t5 sg13_hv_pmos ad=0.34p pd=2.68u as=0.34p ps=2.68u w=1u l=4u
X790 vdd.t85 x1.level_shift_0[7].XM7.D0 x1.level_shift_0[7].out vdd.t0 sg13_hv_pmos ad=0.68p pd=4.68u as=0.38p ps=2.38u w=2u l=0.5u
X791 x1.level_shift_0[1].out x1.level_shift_0[1].XM7.D0 vdd.t175 vdd.t0 sg13_hv_pmos ad=0.38p pd=2.38u as=0.38p ps=2.38u w=2u l=0.5u
X792 x1.xamp.XM6.S0 x1.xamp.vbp2 x1.xamp.XM8.S1 vdd.t6 sg13_hv_pmos ad=0.68p pd=4.68u as=0.68p ps=4.68u w=2u l=4u
X793 x1.XM1.G0 x1.xamp.vbp2 x1.xamp.XM8.D0 vdd.t6 sg13_hv_pmos ad=0.68p pd=4.68u as=0.68p ps=4.68u w=2u l=4u
X794 vss.t11 x1.x1[5].XM7.D0 x1.x1[5].out vss.t247 sg13_hv_nmos ad=0.34p pd=2.68u as=0.19p ps=1.38u w=1u l=0.5u
X795 x1.level_shift_0[2].out x1.level_shift_0[2].XM7.D0 vss.t276 vss.t344 sg13_hv_nmos ad=0.19p pd=1.38u as=0.34p ps=2.68u w=1u l=0.5u
X796 x2.outb1p.t32 x2.vbn1 vss.t95 vss.t418 sg13_hv_nmos ad=0.34p pd=2.68u as=0.34p ps=2.68u w=1u l=1u
X797 x1.level_shift_0[2].XM7.D0 x1.level_shift_0[2].XM7.G0 vss.t276 vss.t344 sg13_hv_nmos ad=0.19p pd=1.38u as=0.34p ps=2.68u w=1u l=0.5u
X798 vdd.t151 x1.x1[0].XM7.G0 x1.x1[0].XM2.D0 vdd.t0 sg13_hv_pmos ad=0.19p pd=1.38u as=0.34p ps=2.68u w=1u l=0.5u
X799 x1.level_shift_0[6].XM7.G0 x1.level_shift_0[6].in_n vss.t167 vss.t172 sg13_hv_nmos ad=1.36p pd=8.68u as=0.76p ps=4.38u w=4u l=0.5u
X800 x1.xamp.out1p x1.xamp.vbn1 vss.t59 vss.t65 sg13_hv_nmos ad=0.34p pd=2.68u as=0.34p ps=2.68u w=1u l=1u
X801 x1.xamp.out1n x1.xamp.vbn1 vss.t59 vss.t77 sg13_hv_nmos ad=0.34p pd=2.68u as=0.34p ps=2.68u w=1u l=1u
X802 x2.outb1n.t10 x2.vbn2 x2.XM9.D0_0 vss.t322 sg13_hv_nmos ad=0.68p pd=4.68u as=0.68p ps=4.68u w=2u l=4u
X803 x1.level_shift_0[6].XM2.D0 trim[2] vss.t167 vss.t239 sg13_hv_nmos ad=1.36p pd=8.68u as=0.76p ps=4.38u w=4u l=0.5u
X804 x1.x1[2].XM7.G0 x1.x1[2].XM2.D0 vdd.t137 vdd.t0 sg13_hv_pmos ad=0.34p pd=2.68u as=0.19p ps=1.38u w=1u l=0.5u
X805 x1.xamp.out1n x1.xamp.vbn1 vss.t59 vss.t65 sg13_hv_nmos ad=0.34p pd=2.68u as=0.34p ps=2.68u w=1u l=1u
X806 vss.t58 x1.level_shift_0[6].XM7.D0 x1.level_shift_0[6].out vss.t126 sg13_hv_nmos ad=0.34p pd=2.68u as=0.19p ps=1.38u w=1u l=0.5u
X807 x1.xamp.out1p x1.xamp.vbn1 vss.t59 vss.t77 sg13_hv_nmos ad=0.34p pd=2.68u as=0.34p ps=2.68u w=1u l=1u
X808 x2.XM9.D0_0 x2.XM9.D0_0 x2.outa1n.t26 vdd.t5 sg13_hv_pmos ad=0.34p pd=2.68u as=0.34p ps=2.68u w=1u l=4u
X809 x2.outb1p.t13 x2.vbn2 x2.XMOP.G0_0 vss.t310 sg13_hv_nmos ad=0.68p pd=4.68u as=0.68p ps=4.68u w=2u l=4u
X810 x2.diffb x2.vbp1 vdd.t252 vdd.t5 sg13_hv_pmos ad=0.34p pd=2.68u as=0.34p ps=2.68u w=1u l=1u
X811 vdd.t90 x1.x1[6].XM7.G0 x1.x1[6].XM7.D0 vdd.t0 sg13_hv_pmos ad=0.38p pd=2.38u as=0.68p ps=4.68u w=2u l=0.5u
X812 x2.diffb x1.vbg x2.outb1p.t3 vdd.t5 sg13_hv_pmos ad=1.36p pd=8.68u as=1.36p ps=8.68u w=4u l=1u
X813 x2.outa1p.t28 x2.XM9.D0_0 x2.XMOP.G0_0 vdd.t5 sg13_hv_pmos ad=0.34p pd=2.68u as=0.34p ps=2.68u w=1u l=4u
X814 x1.level_shift_0[6].out x1.level_shift_0[6].XM7.D0 vdd.t110 vdd.t0 sg13_hv_pmos ad=0.38p pd=2.38u as=0.38p ps=2.38u w=2u l=0.5u
X815 vdd.t162 x1.x1[5].XM7.G0 x1.x1[5].XM2.D0 vdd.t0 sg13_hv_pmos ad=0.19p pd=1.38u as=0.34p ps=2.68u w=1u l=0.5u
X816 vss.t273 vss.t274 vss.t0 rppd l=3.4u w=1.41u
X817 ibias1_250n x1.ena_b_h x1.xamp.vbp2 vdd.t6 sg13_hv_pmos ad=0.68p pd=4.68u as=0.68p ps=4.68u w=2u l=4u
X818 vdd.t148 x1.level_shift_0[0].XM7.G0 x1.level_shift_0[0].XM7.D0 vdd.t0 sg13_hv_pmos ad=0.38p pd=2.38u as=0.68p ps=4.68u w=2u l=0.5u
R0 vbg.n2 vbg.n22 24.9649
R1 vbg.n11 vbg.t20 12.2573
R2 vbg.n14 vbg.t16 12.2545
R3 vbg.n8 vbg.t12 12.1254
R4 vbg.n18 vbg.t8 12.1197
R5 vbg.n14 vbg.t17 10.8887
R6 vbg.n15 vbg.t18 10.8887
R7 vbg.n16 vbg.t19 10.8887
R8 vbg.n11 vbg.t21 10.8878
R9 vbg.n12 vbg.t22 10.8843
R10 vbg.n13 vbg.t23 10.8843
R11 vbg.n9 vbg.t14 10.7138
R12 vbg.n10 vbg.t15 10.7138
R13 vbg.n19 vbg.t10 10.7128
R14 vbg.n20 vbg.t11 10.7128
R15 vbg.n8 vbg.t13 10.7099
R16 vbg.n18 vbg.t9 10.7097
R17 vbg.n21 vbg.n20 6.23091
R18 vbg.n17 vbg.n13 6.04864
R19 vbg.n3 vbg.t5 5.24709
R20 vbg.n5 vbg.t2 5.22949
R21 vbg.n7 vbg.t1 5.22705
R22 vbg.n6 vbg.t4 5.21733
R23 vbg.n3 vbg.t6 5.19438
R24 vbg.n5 vbg.t3 5.18558
R25 vbg.n7 vbg.t7 5.14158
R26 vbg.n6 vbg.t0 5.13278
R27 vbg.n17 vbg.n16 5.08266
R28 vbg vbg.n25 3.9336
R29 vbg.n22 vbg.n21 2.25568
R30 vbg.n1 vbg.n0 1.8382
R31 vbg.n21 vbg.n17 1.54694
R32 vbg.n1 vbg.n2 1.50416
R33 vbg.n25 vbg.n24 1.49642
R34 vbg.n12 vbg.n11 1.42992
R35 vbg.n15 vbg.n14 1.42619
R36 vbg.n10 vbg.n9 1.41599
R37 vbg.n9 vbg.n8 1.41599
R38 vbg.n20 vbg.n19 1.41053
R39 vbg.n19 vbg.n18 1.41053
R40 vbg.n3 vbg.n1 1.37359
R41 vbg.n1 vbg.n5 1.37327
R42 vbg.n13 vbg.n12 1.37
R43 vbg.n16 vbg.n15 1.36628
R44 vbg.n1 vbg.n6 1.36298
R45 vbg.n6 vbg.n23 1.20414
R46 vbg.n0 vbg.n7 0.256555
R47 vbg.n24 vbg.n3 1.18229
R48 vbg.n5 vbg.n4 1.18198
R49 vbg.n22 vbg.n10 1.12952
R50 vbg.n25 vbg.n2 0.477247
R51 vbg.n23 vbg.n4 0.455406
R52 vbg.n24 vbg.n4 0.288292
R53 vbg.n23 vbg.n0 1.00707
R54 vdd.t24 vdd.n55 4.91588
R55 vdd.n59 vdd.t151 10.843
R56 vdd.n42 vdd.t208 10.843
R57 vdd.n43 vdd.t12 10.843
R58 vdd.n18 vdd.t157 10.843
R59 vdd.n19 vdd.t171 10.843
R60 vdd.n21 vdd.t89 10.843
R61 vdd.n20 vdd.t4 10.843
R62 vdd.n25 vdd.t161 10.843
R63 vdd.n24 vdd.t2 10.843
R64 vdd.n5 vdd.t115 10.843
R65 vdd.n4 vdd.t16 10.843
R66 vdd.n2 vdd.t125 10.843
R67 vdd.n3 vdd.t219 10.843
R68 vdd.n13 vdd.t137 10.843
R69 vdd.n12 vdd.t98 10.843
R70 vdd.n8 vdd.t106 10.843
R71 vdd.n9 vdd.t199 10.843
R72 vdd.n49 vdd.t140 10.7007
R73 vdd.n34 vdd.t19 10.683
R74 vdd.n49 vdd.t139 10.663
R75 vdd.n59 vdd.t152 10.1672
R76 vdd.n42 vdd.t211 10.1672
R77 vdd.n43 vdd.t11 10.1672
R78 vdd.n18 vdd.t158 10.1672
R79 vdd.n19 vdd.t170 10.1672
R80 vdd.n21 vdd.t92 10.1672
R81 vdd.n20 vdd.t3 10.1672
R82 vdd.n25 vdd.t162 10.1672
R83 vdd.n24 vdd.t1 10.1672
R84 vdd.n5 vdd.t116 10.1672
R85 vdd.n4 vdd.t15 10.1672
R86 vdd.n2 vdd.t126 10.1672
R87 vdd.n3 vdd.t218 10.1672
R88 vdd.n13 vdd.t138 10.1672
R89 vdd.n12 vdd.t97 10.1672
R90 vdd.n8 vdd.t107 10.1672
R91 vdd.n9 vdd.t198 10.1672
R92 vdd.t50 vdd.t30 10.1635
R93 vdd.t50 vdd.t31 10.1502
R94 vdd.n50 vdd.n67 9.83508
R95 vdd.n34 vdd.t17 9.83508
R96 vdd.n64 vdd.n56 9.83508
R97 vdd.n57 vdd.t21 9.83508
R98 vdd.t26 vdd.t50 9.83508
R99 vdd.n68 vdd.n52 9.83508
R100 vdd.t25 vdd.n50 9.83508
R101 vdd.t19 vdd.n56 9.83508
R102 vdd.n57 vdd.n62 9.83508
R103 vdd.t50 vdd.n70 9.83508
R104 vdd.t28 vdd.n52 9.83508
R105 vdd.n71 vdd.n51 9.83508
R106 vdd.t32 vdd.t50 9.17055
R107 vdd.t23 vdd.n50 9.0005
R108 vdd.n69 vdd.n51 9.0005
R109 vdd.n52 vdd.t29 9.0005
R110 vdd.n66 vdd.t50 9.0005
R111 vdd.n57 vdd.n65 9.0005
R112 vdd.t20 vdd.n54 4.45336
R113 vdd.n50 vdd.n61 9.0005
R114 vdd.t18 vdd.n34 9.0005
R115 vdd.t30 vdd.n51 9.0005
R116 vdd.n72 vdd.n52 9.0005
R117 vdd.t27 vdd.t50 9.0005
R118 vdd.t22 vdd.n57 9.0005
R119 vdd.n56 vdd.n63 9.0005
R120 vdd.n49 vdd.t292 7.47337
R121 vdd.t6 vdd.n60 7.65246
R122 vdd.n16 vdd.t59 5.68661
R123 vdd.n39 vdd.t209 5.68661
R124 vdd.n40 vdd.t88 5.68661
R125 vdd.n28 vdd.t235 5.68661
R126 vdd.n17 vdd.t111 5.68661
R127 vdd.n23 vdd.t90 5.68661
R128 vdd.n22 vdd.t194 5.68661
R129 vdd.n27 vdd.t159 5.68661
R130 vdd.n26 vdd.t10 5.68661
R131 vdd.n7 vdd.t113 5.68661
R132 vdd.n6 vdd.t14 5.68661
R133 vdd.n0 vdd.t180 5.68661
R134 vdd.n1 vdd.t233 5.68661
R135 vdd.n15 vdd.t132 5.68661
R136 vdd.n14 vdd.t175 5.68661
R137 vdd.n11 vdd.t153 5.68661
R138 vdd.n10 vdd.t148 5.68661
R139 vdd.t0 vdd.t57 5.61259
R140 vdd.n44 vdd.t238 5.61259
R141 vdd.n41 vdd.t86 5.61259
R142 vdd.n46 vdd.t288 5.61259
R143 vdd.n45 vdd.t109 5.61259
R144 vdd.t0 vdd.t212 5.61259
R145 vdd.n36 vdd.t247 5.61259
R146 vdd.t0 vdd.t242 5.61259
R147 vdd.t0 vdd.t8 5.61259
R148 vdd.n47 vdd.t163 5.61259
R149 vdd.n37 vdd.t94 5.61259
R150 vdd.t0 vdd.t178 5.61259
R151 vdd.t0 vdd.t231 5.61259
R152 vdd.n48 vdd.t130 5.61259
R153 vdd.n38 vdd.t173 5.61259
R154 vdd.t0 vdd.t220 5.61259
R155 vdd.t0 vdd.t146 5.61259
R156 vdd.t0 vdd.t58 4.63383
R157 vdd.n16 vdd.t60 4.63383
R158 vdd.n44 vdd.t239 4.63383
R159 vdd.n41 vdd.t85 4.63383
R160 vdd.n39 vdd.t210 4.63383
R161 vdd.n40 vdd.t87 4.63383
R162 vdd.n46 vdd.t289 4.63383
R163 vdd.n45 vdd.t108 4.63383
R164 vdd.n28 vdd.t236 4.63383
R165 vdd.n17 vdd.t110 4.63383
R166 vdd.t0 vdd.t213 4.63383
R167 vdd.n36 vdd.t246 4.63383
R168 vdd.n23 vdd.t91 4.63383
R169 vdd.n22 vdd.t193 4.63383
R170 vdd.t0 vdd.t243 4.63383
R171 vdd.t0 vdd.t7 4.63383
R172 vdd.n27 vdd.t160 4.63383
R173 vdd.n26 vdd.t9 4.63383
R174 vdd.n47 vdd.t164 4.63383
R175 vdd.n37 vdd.t93 4.63383
R176 vdd.n7 vdd.t114 4.63383
R177 vdd.n6 vdd.t13 4.63383
R178 vdd.t0 vdd.t179 4.63383
R179 vdd.t0 vdd.t230 4.63383
R180 vdd.n0 vdd.t181 4.63383
R181 vdd.n1 vdd.t232 4.63383
R182 vdd.n48 vdd.t131 4.63383
R183 vdd.n38 vdd.t172 4.63383
R184 vdd.n15 vdd.t133 4.63383
R185 vdd.n14 vdd.t174 4.63383
R186 vdd.t0 vdd.t221 4.63383
R187 vdd.t0 vdd.t145 4.63383
R188 vdd.n11 vdd.t154 4.63383
R189 vdd.n10 vdd.t147 4.63383
R190 vdd.n35 vdd.t34 3.73611
R191 vdd.n49 vdd.t104 3.62758
R192 vdd.n49 vdd.t105 3.62758
R193 vdd.n49 vdd.t103 3.62758
R194 vdd.n49 vdd.t102 3.62758
R195 vdd.n60 vdd.t0 3.15698
R196 vdd.t50 vdd.t6 1.9619
R197 vdd.t5 vdd.n53 1.75906
R198 vdd.n33 vdd.n57 0.554648
R199 vdd.n57 vdd.n56 1.74659
R200 vdd.n52 vdd.n51 1.70515
R201 vdd.t5 vdd.n58 1.69277
R202 vdd.t83 vdd.n53 1.63773
R203 vdd.t6 vdd.t5 1.62631
R204 vdd.t0 vdd.n0 1.61528
R205 vdd.n49 vdd.t101 1.60325
R206 vdd.n32 vdd.n31 0.537888
R207 vdd.n32 vdd.n52 0.427224
R208 vdd.n51 vdd.n30 1.5005
R209 vdd.n50 vdd.n33 0.554648
R210 vdd.n29 vdd.n33 0.474176
R211 vdd.n56 vdd.n35 1.5005
R212 vdd.n35 vdd.n34 1.5005
R213 vdd.n58 vdd.t83 1.48697
R214 vdd.n62 vdd.t19 1.47866
R215 vdd.n55 vdd.t50 1.46751
R216 vdd.t0 vdd.n28 1.46144
R217 vdd.t50 vdd.n50 1.45332
R218 vdd.t5 vdd.t252 1.41339
R219 vdd.t0 vdd.n44 1.41311
R220 vdd.n35 vdd.n29 1.39991
R221 vdd.n31 vdd.n29 1.39991
R222 vdd.n31 vdd.n30 1.39991
R223 vdd.n60 vdd.n49 1.28641
R224 vdd.t5 vdd.t99 1.23187
R225 vdd.t112 vdd.t121 1.2293
R226 vdd.t99 vdd.t112 1.2101
R227 vdd.n54 vdd.n56 0.538697
R228 vdd.n58 vdd.t81 1.20695
R229 vdd.t121 vdd.t252 1.18832
R230 vdd.t30 vdd.n72 1.16353
R231 vdd.n70 vdd.t28 1.16353
R232 vdd.n67 vdd.t26 1.16353
R233 vdd.n68 vdd.t24 1.16353
R234 vdd.n64 vdd.t21 1.16353
R235 vdd.n63 vdd.t22 1.16353
R236 vdd.n62 vdd.t25 1.16353
R237 vdd.n61 vdd.t27 1.16353
R238 vdd.t26 vdd.n68 1.16353
R239 vdd.n67 vdd.t21 1.16353
R240 vdd.t17 vdd.n64 1.16353
R241 vdd.t29 vdd.n69 1.16353
R242 vdd.t23 vdd.n66 1.16353
R243 vdd.t28 vdd.n71 1.16353
R244 vdd.n70 vdd.t25 1.16353
R245 vdd.n72 vdd.t27 1.16353
R246 vdd.n61 vdd.t22 1.16353
R247 vdd.n63 vdd.t18 1.16353
R248 vdd.n65 vdd.t23 1.16353
R249 vdd.t29 vdd.n66 1.16353
R250 vdd vdd.t6 1.10506
R251 vdd.t0 vdd.n59 1.10284
R252 vdd.t34 vdd.t6 1.07039
R253 vdd.n69 vdd.t32 0.993473
R254 vdd.n44 vdd.n43 0.93858
R255 vdd.t0 vdd.n19 0.93858
R256 vdd.t0 vdd.n20 0.93858
R257 vdd.t0 vdd.n24 0.93858
R258 vdd.t0 vdd.n4 0.93858
R259 vdd.t0 vdd.n3 0.93858
R260 vdd.t0 vdd.n12 0.93858
R261 vdd.t0 vdd.n9 0.93858
R262 vdd.n44 vdd.n42 0.93506
R263 vdd.t0 vdd.n18 0.93506
R264 vdd.t0 vdd.n21 0.93506
R265 vdd.t0 vdd.n25 0.93506
R266 vdd.t0 vdd.n5 0.93506
R267 vdd.t0 vdd.n2 0.93506
R268 vdd.t0 vdd.n13 0.93506
R269 vdd.t0 vdd.n8 0.93506
R270 vdd.n71 vdd.t31 0.848392
R271 vdd.t0 vdd.n16 0.71609
R272 vdd.n44 vdd.n40 0.71389
R273 vdd.t0 vdd.n17 0.71389
R274 vdd.t0 vdd.n22 0.71389
R275 vdd.t0 vdd.n26 0.71389
R276 vdd.t0 vdd.n6 0.71389
R277 vdd.t0 vdd.n1 0.71389
R278 vdd.t0 vdd.n14 0.71389
R279 vdd.t0 vdd.n10 0.71389
R280 vdd.n44 vdd.n39 0.70949
R281 vdd.t0 vdd.n23 0.70949
R282 vdd.t0 vdd.n27 0.70949
R283 vdd.t0 vdd.n7 0.70949
R284 vdd.t0 vdd.n15 0.70949
R285 vdd.t0 vdd.n11 0.70949
R286 vdd.t50 vdd.n30 1.39232
R287 vdd.t81 vdd.n53 1.3558
R288 vdd.t0 vdd.n38 1.35326
R289 vdd.t0 vdd.n37 1.35326
R290 vdd.t0 vdd.n36 1.35326
R291 vdd.t0 vdd.n45 1.34886
R292 vdd.n44 vdd.n41 1.34886
R293 vdd.t0 vdd.n48 1.34446
R294 vdd.t0 vdd.n47 1.34446
R295 vdd.t0 vdd.n46 1.34446
R296 vdd.n65 vdd.t20 1.33358
R297 vdd.n32 vdd.t50 1.28603
R298 vdd.n54 vdd.n34 1.13831
R299 vdd.n55 vdd.n51 1.06586
R300 vss.n263 vss.n85 1.758e+06
R301 vss.t59 vss.n268 1.1892e+06
R302 vss.t53 vss.n85 1.0275e+06
R303 vss.t53 vss.t50 496572
R304 vss.n268 vss.t22 320077
R305 vss.t41 vss.t44 149837
R306 vss.n266 vss.n265 115691
R307 vss.n246 vss.n85 105531
R308 vss.n207 vss.n206 81553.9
R309 vss.n207 vss.n202 73699.3
R310 vss.n268 vss.t95 61866.2
R311 vss.n265 vss.n264 58127.7
R312 vss.n267 vss.n266 52347.7
R313 vss.n103 vss.t34 46262.1
R314 vss.n190 vss.n189 44086.5
R315 vss.n202 vss.n89 29665.2
R316 vss.n260 vss.n89 28498.5
R317 vss.t59 vss.t44 17237.6
R318 vss.n263 vss.n262 16263.2
R319 vss.n261 vss.n260 15312.4
R320 vss.n264 vss.n263 14380.1
R321 vss.n262 vss.n261 13315.8
R322 vss.n261 vss.n29 12159
R323 vss.n247 vss.n84 11176.6
R324 vss.n247 vss.t47 11054.3
R325 vss.n265 vss.n84 8494.57
R326 vss.n265 vss.t50 6995.97
R327 vss.n246 vss.n55 5467.74
R328 vss.n203 vss.t30 4161.93
R329 vss.t351 vss.t95 3643.09
R330 vss.t306 vss.t305 3377.9
R331 vss.t307 vss.t306 3328.18
R332 vss.t310 vss.t311 3281.77
R333 vss.t309 vss.t308 3241.99
R334 vss.t311 vss.t312 3241.99
R335 vss.t312 vss.t313 3241.99
R336 vss.t313 vss.t314 3241.99
R337 vss.t308 vss.n135 3135.91
R338 vss.t300 vss.t301 3043.03
R339 vss.n260 vss.t41 3038.82
R340 vss.t301 vss.t302 3006.15
R341 vss.t302 vss.t303 3006.15
R342 vss.t303 vss.t304 3006.15
R343 vss.n267 vss.t304 2787.91
R344 vss.t358 vss.t20 2619.26
R345 vss.t95 vss.t305 2390.06
R346 vss.t297 vss.t310 2356.91
R347 vss.t95 vss.t300 2176.23
R348 vss.n202 vss.t34 2085.89
R349 vss.n56 vss.n55 2046.57
R350 vss.n206 vss.t358 2028.45
R351 vss.t20 vss.n204 2015.32
R352 vss.n245 vss.n244 1880.36
R353 vss.n91 vss.n90 1874.09
R354 vss.t47 vss.n246 1451.61
R355 vss.n103 vss.t59 1365.91
R356 vss.t348 vss.t22 1253.04
R357 vss.t23 vss.t348 1253.04
R358 vss.t349 vss.t23 1253.04
R359 vss.t24 vss.t350 1253.04
R360 vss.t350 vss.t25 1253.04
R361 vss.t25 vss.t351 1253.04
R362 vss.n204 vss.n203 899.345
R363 vss.t297 vss.t309 885.083
R364 vss.t95 vss.t349 692.818
R365 vss.t267 vss.t377 581.717
R366 vss.t261 vss.t376 581.717
R367 vss.t346 vss.t277 581.717
R368 vss.t275 vss.t344 581.717
R369 vss.t95 vss.t24 580.111
R370 vss.n244 vss.t53 542.144
R371 vss.n91 vss.t44 540.822
R372 vss.t95 vss.t314 2466.73
R373 vss.n56 vss.n57 1.11247
R374 vss.t118 vss.t404 426.401
R375 vss.n264 vss.n55 419.567
R376 vss.t95 vss.t144 165.941
R377 vss.n163 vss.t258 400.971
R378 vss.n163 vss.t347 394.738
R379 vss.t96 vss.t26 382.849
R380 vss.t26 vss.t99 382.849
R381 vss.t99 vss.t27 382.849
R382 vss.t405 vss.t389 382.849
R383 vss.t408 vss.t410 382.849
R384 vss.t410 vss.t411 382.849
R385 vss.t409 vss.t390 382.849
R386 vss.t413 vss.t387 382.849
R387 vss.t414 vss.t415 382.849
R388 vss.t416 vss.t417 382.849
R389 vss.t417 vss.t418 382.849
R390 vss.t419 vss.t421 382.849
R391 vss.t420 vss.t422 382.849
R392 vss.t422 vss.t388 382.849
R393 vss.t424 vss.t425 382.849
R394 vss.t112 vss.t401 379.812
R395 vss.t113 vss.t402 379.812
R396 vss.t318 vss.t409 378.798
R397 vss.t105 vss.t352 376.772
R398 vss.t107 vss.t28 376.772
R399 vss.t109 vss.t353 376.772
R400 vss.t95 vss.t29 325.618
R401 vss.t95 vss.t146 169.071
R402 vss.t421 vss.t323 374.748
R403 vss.t258 vss.t261 365.651
R404 vss.t347 vss.t346 365.651
R405 vss.t344 vss.t342 365.651
R406 vss.t453 vss.t379 358.363
R407 vss.t137 vss.t452 358.363
R408 vss.t270 vss.t249 358.363
R409 vss.t243 vss.t269 358.363
R410 vss.t236 vss.t289 358.363
R411 vss.t176 vss.t235 358.363
R412 vss.t163 vss.t6 358.363
R413 vss.t265 vss.t162 358.363
R414 vss.t294 vss.t139 358.363
R415 vss.t170 vss.t293 358.363
R416 vss.t232 vss.t10 358.363
R417 vss.t248 vss.t231 358.363
R418 vss.t123 vss.t339 358.363
R419 vss.t156 vss.t121 358.363
R420 vss.t375 vss.t334 358.363
R421 vss.t355 vss.t374 358.363
R422 vss.t19 vss.t142 358.363
R423 vss.t296 vss.t17 358.363
R424 vss.n245 vss.t50 345.817
R425 vss.t41 vss.n90 342.882
R426 vss.t320 vss.t414 311.952
R427 vss.t315 vss.t403 308.913
R428 vss.t415 vss.t321 307.901
R429 vss.t95 vss.t400 302.849
R430 vss.n47 vss.t34 295.635
R431 vss.t41 vss.n51 295.635
R432 vss.t404 vss.t316 293.721
R433 vss.t95 vss.t96 291.183
R434 vss.t268 vss.t267 254.642
R435 vss.n255 vss.t34 252.51
R436 vss.n173 vss.t134 247.014
R437 vss.n175 vss.t241 247.014
R438 vss.n177 vss.t174 247.014
R439 vss.n179 vss.t263 247.014
R440 vss.n181 vss.t169 247.014
R441 vss.n183 vss.t247 247.014
R442 vss.n185 vss.t154 247.014
R443 vss.n187 vss.t354 247.014
R444 vss.n189 vss.t295 247.014
R445 vss.t381 vss.n29 243.174
R446 vss.t250 vss.n173 243.174
R447 vss.t290 vss.n175 243.174
R448 vss.t8 vss.n177 243.174
R449 vss.t140 vss.n179 243.174
R450 vss.t12 vss.n181 243.174
R451 vss.t340 vss.n183 243.174
R452 vss.t335 vss.n185 243.174
R453 vss.t143 vss.n187 243.174
R454 vss.t292 vss.t13 236.353
R455 vss.t291 vss.t223 236.353
R456 vss.t322 vss.t419 232.952
R457 vss.t390 vss.t319 228.899
R458 vss.n266 vss.t389 226.875
R459 vss.t379 vss.t381 225.256
R460 vss.t134 vss.t137 225.256
R461 vss.t249 vss.t250 225.256
R462 vss.t241 vss.t243 225.256
R463 vss.t289 vss.t290 225.256
R464 vss.t174 vss.t176 225.256
R465 vss.t6 vss.t8 225.256
R466 vss.t263 vss.t265 225.256
R467 vss.t139 vss.t140 225.256
R468 vss.t169 vss.t170 225.256
R469 vss.t10 vss.t12 225.256
R470 vss.t247 vss.t248 225.256
R471 vss.t339 vss.t340 225.256
R472 vss.t154 vss.t156 225.256
R473 vss.t334 vss.t335 225.256
R474 vss.t354 vss.t355 225.256
R475 vss.t142 vss.t143 225.256
R476 vss.t295 vss.t296 225.256
R477 vss.t0 vss.n208 223.757
R478 vss.t30 vss.n160 223.196
R479 vss.n209 vss.t56 218.37
R480 vss.t388 vss.t324 216.745
R481 vss.t27 vss.t95 207.945
R482 vss.t95 vss.t413 204.697
R483 vss.n135 vss.t408 188.387
R484 vss.t377 vss.n157 184.904
R485 vss.t277 vss.n161 184.904
R486 vss.t376 vss.n157 180.749
R487 vss.n161 vss.t275 180.749
R488 vss.t103 vss.t95 171.476
R489 vss.t412 vss.t95 170.262
R490 vss.t324 vss.t424 166.105
R491 vss.t221 vss.n159 162.916
R492 vss.t317 vss.t407 162.054
R493 vss.t15 vss.n88 160.383
R494 vss.n159 vss.t268 160.383
R495 vss.n266 vss.t407 155.976
R496 vss.t319 vss.t412 153.951
R497 vss.t418 vss.t322 149.899
R498 vss.t13 vss.t15 148.565
R499 vss.t223 vss.t221 148.565
R500 vss.t342 vss.n160 147.507
R501 vss.t56 vss.n199 140.47
R502 vss.n208 vss.n207 140.055
R503 vss.n209 vss.t0 135.498
R504 vss.t239 vss.t131 122.653
R505 vss.t126 vss.t124 119.338
R506 vss.n172 vss.t453 113.909
R507 vss.n174 vss.t270 113.909
R508 vss.n176 vss.t236 113.909
R509 vss.n178 vss.t163 113.909
R510 vss.n180 vss.t294 113.909
R511 vss.n182 vss.t232 113.909
R512 vss.n184 vss.t123 113.909
R513 vss.n186 vss.t375 113.909
R514 vss.n188 vss.t19 113.909
R515 vss.t179 vss.t180 111.526
R516 vss.t452 vss.n172 111.349
R517 vss.t269 vss.n174 111.349
R518 vss.t235 vss.n176 111.349
R519 vss.t162 vss.n178 111.349
R520 vss.t293 vss.n180 111.349
R521 vss.t231 vss.n182 111.349
R522 vss.t121 vss.n184 111.349
R523 vss.t374 vss.n186 111.349
R524 vss.t17 vss.n188 111.349
R525 vss.t60 vss.t75 110.951
R526 vss.n37 vss.n148 106.582
R527 vss.n135 vss.t307 106.078
R528 vss.n261 vss.n88 97.9183
R529 vss.t131 vss.n195 96.1331
R530 vss.t65 vss.t59 93.7056
R531 vss.t124 vss.n190 91.9895
R532 vss.t316 vss.t405 89.1295
R533 vss.t59 vss.t181 86.5878
R534 vss.t180 vss.t59 85.6573
R535 vss.t59 vss.t77 79.2223
R536 vss.n170 vss.t292 75.1271
R537 vss.t321 vss.t416 74.9499
R538 vss.n170 vss.t291 73.4389
R539 vss.n207 vss.t3 71.8602
R540 vss.t116 vss.t315 70.8985
R541 vss.t387 vss.t320 70.8985
R542 vss.n24 vss.t425 306.373
R543 vss.n203 vss.n199 62.1552
R544 vss.t3 vss.t363 61.225
R545 vss.t363 vss.t164 61.225
R546 vss.t164 vss.t336 61.225
R547 vss.t336 vss.t129 61.225
R548 vss.t129 vss.t1 61.225
R549 vss.t9 vss.t141 61.225
R550 vss.t141 vss.t384 61.225
R551 vss.t384 vss.t2 61.225
R552 vss.t2 vss.t161 61.225
R553 vss.t244 vss.t233 61.225
R554 vss.t225 vss.t244 61.225
R555 vss.t378 vss.t225 61.225
R556 vss.t130 vss.t378 61.225
R557 vss.t228 vss.t130 61.225
R558 vss.t286 vss.t255 61.225
R559 vss.t255 vss.t341 61.225
R560 vss.t341 vss.t184 61.225
R561 vss.t184 vss.t234 61.225
R562 vss.n39 vss.n41 60.0853
R563 vss.n104 vss.t228 59.7878
R564 vss.n24 vss.n267 27.8362
R565 vss.t234 vss.n103 53.1767
R566 vss.n42 vss.n70 1.15045
R567 vss.n97 vss.t9 50.3023
R568 vss.n256 vss.t44 50.0835
R569 vss.t41 vss.n259 50.0835
R570 vss.t53 vss.n100 49.4977
R571 vss.n95 vss.t34 44.4858
R572 vss.n203 vss.n195 43.9232
R573 vss.n57 vss.t50 74.1464
R574 vss.n92 vss.n89 40.4183
R575 vss.n254 vss.n89 40.4183
R576 vss.n262 vss.n87 38.9539
R577 vss.n262 vss.n86 38.9539
R578 vss.n96 vss.t16 33.9183
R579 vss.t16 vss.n94 33.3434
R580 vss.n135 vss.t317 32.411
R581 vss.t233 vss.n94 27.8821
R582 vss.t161 vss.n96 27.3072
R583 vss.n198 vss.t126 22.7906
R584 vss.n214 vss.n160 20.8275
R585 vss.n198 vss.t172 13.6745
R586 vss vss.n83 11.1116
R587 vss.t1 vss.n97 10.9232
R588 vss.t95 vss.t297 9.22181
R589 vss.n206 vss.t4 8.65648
R590 vss.n204 vss.t4 8.73751
R591 vss.t36 vss.n107 8.5005
R592 vss.n115 vss.t43 8.5005
R593 vss.n99 vss.t40 8.5005
R594 vss.n96 vss.t59 8.36416
R595 vss.n30 vss.n215 9.06693
R596 vss.t323 vss.t420 8.10313
R597 vss.t273 vss.n23 0.181295
R598 vss.n205 vss.n83 6.21242
R599 vss.t352 vss.t103 6.07747
R600 vss.t28 vss.t105 6.07747
R601 vss.t353 vss.t107 6.07747
R602 vss.t29 vss.t109 6.07747
R603 vss.t55 vss.n23 2.98003
R604 vss.n237 vss.n236 5.91913
R605 vss.n241 vss.n126 5.87513
R606 vss.t95 vss.t298 3.97067
R607 vss.n143 vss.n130 5.73646
R608 vss.n238 vss.n237 5.73287
R609 vss.n137 vss.n129 5.55307
R610 vss.n0 vss.n125 5.50541
R611 vss.n140 vss.n139 5.31391
R612 vss.n241 vss.n240 5.05956
R613 vss.n144 vss.n143 4.95001
R614 vss.n142 vss.n141 4.94684
R615 vss.n230 vss.n132 4.56236
R616 vss.n140 vss.n127 4.5005
R617 vss.n232 vss.t380 4.39403
R618 vss.t411 vss.t318 4.05182
R619 vss.n258 vss.n91 3.93832
R620 vss.n146 vss.n137 3.93594
R621 vss.n234 vss.n132 3.46142
R622 vss.n211 vss.t57 3.16559
R623 vss.t63 vss.n211 3.10229
R624 vss.t400 vss.t112 3.03899
R625 vss.t401 vss.t113 3.03899
R626 vss.t402 vss.t116 3.03899
R627 vss.t403 vss.t118 3.03899
R628 vss.n200 vss.n83 2.98103
R629 vss.n37 vss.t95 2.9662
R630 vss.n239 vss.n238 2.85773
R631 vss.n201 vss.n200 2.76456
R632 vss.n257 vss.n90 2.49726
R633 vss.n46 vss.n152 2.41316
R634 vss.n244 vss.n243 2.3853
R635 vss.n37 vss.n36 0.563042
R636 vss.n150 vss.n136 2.2505
R637 vss.n152 vss.n151 2.2505
R638 vss.n44 vss.n149 2.2505
R639 vss.n240 vss.n239 2.2505
R640 vss.n146 vss.n145 2.2505
R641 vss.n147 vss.n125 2.2505
R642 vss.n236 vss.n235 2.2505
R643 vss.n153 vss.n126 2.2505
R644 vss.n138 vss.n131 2.2505
R645 vss.n235 vss.n234 2.24958
R646 vss.n113 vss.t38 1.94014
R647 vss.n122 vss.t52 1.94014
R648 vss.t33 vss.n252 1.93693
R649 vss.n121 vss.t49 1.93639
R650 vss.n251 vss.t46 1.93639
R651 vss.t61 vss.n116 1.93586
R652 vss.n118 vss.t61 1.93479
R653 vss.t49 vss.n119 1.93426
R654 vss.t46 vss.n249 1.93426
R655 vss.n253 vss.t33 1.93372
R656 vss.n123 vss.n2 1.93101
R657 vss.n53 vss.n102 1.93101
R658 vss.t52 vss.n2 1.93053
R659 vss.t38 vss.n102 1.93053
R660 vss.n253 vss.n72 1.89761
R661 vss.n75 vss.n119 1.89204
R662 vss.n64 vss.n249 1.89204
R663 vss.n118 vss.n117 1.88647
R664 vss.n76 vss.n116 1.87532
R665 vss.n121 vss.n120 1.86974
R666 vss.n251 vss.n250 1.86974
R667 vss.n61 vss.n252 1.86417
R668 vss.n113 vss.n112 1.83068
R669 vss.n122 vss.n3 1.83068
R670 vss.n169 vss.n168 1.77757
R671 vss.t95 vss.n133 1.74738
R672 vss.n80 vss.n56 1.7005
R673 vss.n49 vss.n51 1.7005
R674 vss.n47 vss.n93 1.7005
R675 vss.n255 vss.n93 1.7005
R676 vss.n255 vss.n79 1.7005
R677 vss.n105 vss.n79 1.7005
R678 vss.n39 vss.n257 1.7005
R679 vss.n3 vss.n39 0.263361
R680 vss.n42 vss.n39 1.61022
R681 vss.n4 vss.n3 0.130855
R682 vss.n59 vss.n51 1.7005
R683 vss.n257 vss.n59 1.7005
R684 vss.n56 vss.n67 1.7005
R685 vss.n248 vss.n67 1.7005
R686 vss.t111 vss.t115 1.69909
R687 vss.n235 vss.n131 1.68594
R688 vss.t95 vss.n134 1.67357
R689 vss.t172 vss.t239 1.65796
R690 vss.n147 vss.n146 1.65661
R691 vss.n153 vss.n131 1.65661
R692 vss.t298 vss.t119 1.64695
R693 vss vss.t59 1.56088
R694 vss.n233 vss.n46 1.55419
R695 vss.n46 vss.n37 1.52797
R696 vss.n248 vss.n245 1.51766
R697 vss.n134 vss.t145 1.47109
R698 vss.n104 vss.t286 1.43769
R699 vss.n205 vss.n201 1.42552
R700 vss.t259 vss.t14 1.41635
R701 vss.n32 vss.t58 0.296913
R702 vss.t147 vss.n133 1.41472
R703 vss.n56 vss.n66 1.21479
R704 vss.n248 vss.n247 1.21479
R705 vss.n41 vss.n248 1.21479
R706 vss.n243 vss.n84 1.21479
R707 vss.n51 vss.n86 1.21479
R708 vss.n69 vss.n51 1.21479
R709 vss.n56 vss.n100 1.21479
R710 vss.n56 vss.n69 1.21479
R711 vss.n254 vss.n47 1.21479
R712 vss.n47 vss.n74 1.21479
R713 vss.n255 vss.n254 1.21479
R714 vss.n82 vss.n255 1.21479
R715 vss.n256 vss.n51 1.21479
R716 vss.n74 vss.n51 1.21479
R717 vss.n257 vss.n256 1.21479
R718 vss.n257 vss.n82 1.21479
R719 vss.n47 vss.n97 1.21479
R720 vss.n48 vss.n62 0.250582
R721 vss.n255 vss.n94 1.21479
R722 vss.n255 vss.n78 1.21479
R723 vss.n259 vss.n258 1.21479
R724 vss.n243 vss.n87 1.21479
R725 vss.n243 vss.n39 0.667562
R726 vss.n105 vss.n54 1.21479
R727 vss.n258 vss.n92 1.21479
R728 vss.n258 vss.n4 0.146299
R729 vss.n105 vss.n104 1.21479
R730 vss.n257 vss.n86 1.21479
R731 vss.n257 vss.n70 1.21479
R732 vss.n248 vss.n101 1.21479
R733 vss.n248 vss.n42 0.0388231
R734 vss.t47 vss.n57 0.10071
R735 vss.t299 vss.t95 4.53525
R736 vss.n134 vss.t148 1.18854
R737 vss.n256 vss.n92 1.17203
R738 vss.n101 vss.n100 1.17203
R739 vss.n259 vss.n86 1.17203
R740 vss.t95 vss.t391 1.16967
R741 vss.n228 vss.n227 1.16179
R742 vss.n226 vss.n225 1.16179
R743 vss.n224 vss.n223 1.16179
R744 vss.n222 vss.n221 1.16179
R745 vss.n220 vss.n219 1.16179
R746 vss.n218 vss.n217 1.16179
R747 vss.n168 vss.n167 1.16179
R748 vss.n166 vss.n165 1.16179
R749 vss.n164 vss.n162 1.16179
R750 vss.n191 vss.n171 1.16179
R751 vss.n194 vss.n193 1.16179
R752 vss.n213 vss.n197 1.16179
R753 vss.n196 vss.n156 1.16179
R754 vss.n40 vss.t273 0.357174
R755 vss.n229 vss.n228 1.15079
R756 vss.n227 vss.n226 1.15079
R757 vss.n225 vss.n224 1.15079
R758 vss.n223 vss.n222 1.15079
R759 vss.n221 vss.n220 1.15079
R760 vss.n219 vss.n218 1.15079
R761 vss.n217 vss.n216 1.15079
R762 vss.n216 vss.n30 1.70731
R763 vss.t95 vss.n24 1.59455
R764 vss.n167 vss.n166 1.15079
R765 vss.n165 vss.n164 1.15079
R766 vss.n191 vss.n162 1.15079
R767 vss.n194 vss.n171 1.15079
R768 vss.n213 vss.n193 1.15079
R769 vss.n197 vss.n196 1.15079
R770 vss.n115 vss.n114 1.14863
R771 vss.n3 vss.n115 1.14863
R772 vss.n25 vss.n29 1.13383
R773 vss.n189 vss.n25 1.13383
R774 vss.t58 vss.n214 0.425051
R775 vss.n214 vss.n88 1.13383
R776 vss.n214 vss.n159 1.13383
R777 vss.n214 vss.n158 1.13383
R778 vss.n214 vss.n163 1.13383
R779 vss.n214 vss.n6 1.13383
R780 vss.n214 vss.n192 1.13383
R781 vss.n214 vss.n9 1.13383
R782 vss.n173 vss.n25 1.13383
R783 vss.n155 vss.n25 1.13383
R784 vss.n175 vss.n25 1.13383
R785 vss.n19 vss.n25 1.13383
R786 vss.n177 vss.n25 1.13383
R787 vss.n179 vss.n25 1.13383
R788 vss.n15 vss.n25 1.13383
R789 vss.n181 vss.n25 1.13383
R790 vss.n183 vss.n25 1.13383
R791 vss.n12 vss.n25 1.13383
R792 vss.n185 vss.n25 1.13383
R793 vss.n187 vss.n25 1.13383
R794 vss.n99 vss.n73 1.128
R795 vss.n68 vss.n99 1.128
R796 vss.t149 vss.n133 1.1255
R797 vss.t21 vss.t4 1.1255
R798 vss.t391 vss.t120 1.12428
R799 vss.n77 vss.n107 1.11425
R800 vss.n108 vss.n107 1.11425
R801 vss.n230 vss.n229 1.1115
R802 vss.t4 vss.t5 1.10488
R803 vss.n215 vss.n156 1.1005
R804 vss.n25 vss.n31 0.336877
R805 vss.n105 vss.n95 1.05535
R806 vss.n231 vss.n230 1.04897
R807 vss.n239 vss.n128 1.00942
R808 vss.n148 vss.n147 1.0083
R809 vss.n45 vss.n153 1.00732
R810 vss.n164 vss.n7 1.4699
R811 vss.n196 vss.n33 1.30996
R812 vss.n27 vss.n33 0.275026
R813 vss.n216 vss.n26 1.40521
R814 vss.n13 vss.n12 0.944094
R815 vss.n218 vss.n12 0.944094
R816 vss.n220 vss.n16 1.39024
R817 vss.n17 vss.n15 0.944094
R818 vss.n222 vss.n15 0.944094
R819 vss.n224 vss.n20 1.39024
R820 vss.n21 vss.n19 0.944094
R821 vss.n226 vss.n19 0.944094
R822 vss.n155 vss.n34 0.944094
R823 vss.n228 vss.n155 0.944094
R824 vss.n28 vss.n213 1.39024
R825 vss.n9 vss.n194 0.944094
R826 vss.n10 vss.n9 0.944094
R827 vss.n192 vss.n191 0.944094
R828 vss.n5 vss.n192 0.944094
R829 vss.n166 vss.n6 0.944094
R830 vss.t4 vss.n6 0.944094
R831 vss.n168 vss.n158 0.944094
R832 vss.n212 vss.n158 0.944094
R833 vss.n238 vss.n127 0.920429
R834 vss.n20 vss.n25 0.153437
R835 vss.n16 vss.n25 0.153437
R836 vss.n26 vss.n25 0.12212
R837 vss.n229 vss.n25 0.8505
R838 vss.n227 vss.n25 0.8505
R839 vss.n225 vss.n25 0.8505
R840 vss.n223 vss.n25 0.8505
R841 vss.n221 vss.n25 0.8505
R842 vss.n219 vss.n25 0.8505
R843 vss.n217 vss.n25 0.8505
R844 vss.n30 vss.n25 0.0547231
R845 vss.n7 vss.t4 0.440966
R846 vss.n214 vss.n28 0.153437
R847 vss.n214 vss.n33 0.330128
R848 vss.n214 vss.n7 0.0635257
R849 vss.n214 vss.n167 0.8505
R850 vss.n214 vss.n165 0.8505
R851 vss.n214 vss.n162 0.8505
R852 vss.n214 vss.n171 0.8505
R853 vss.n214 vss.n193 0.8505
R854 vss.n214 vss.n197 0.8505
R855 vss.n214 vss.n156 0.8505
R856 vss.t43 vss.n1 0.833276
R857 vss.t40 vss.n98 0.828105
R858 vss.n109 vss.t36 0.824689
R859 vss.n109 vss.n108 0.804724
R860 vss.n77 vss.n109 0.804111
R861 vss.n68 vss.n98 0.797639
R862 vss.n98 vss.n73 0.797028
R863 vss.t115 vss.t299 0.796795
R864 vss.n3 vss.n1 0.786917
R865 vss.n114 vss.n1 0.786309
R866 vss.n11 vss.t125 0.242764
R867 vss.t125 vss.t132 0.781152
R868 vss.n8 vss.t259 0.242764
R869 vss.t271 vss.t167 0.781152
R870 vss.n14 vss.t11 0.242729
R871 vss.n18 vss.t7 0.242729
R872 vss.n22 vss.t242 0.242729
R873 vss.t177 vss.t7 0.780968
R874 vss.t171 vss.t11 0.780968
R875 vss.t122 vss.t155 0.780968
R876 vss.t135 vss.t242 0.780968
R877 vss.n66 vss.n65 0.742045
R878 vss.n44 vss.n36 0.0101298
R879 vss.n233 vss.n232 0.722313
R880 vss.n50 vss.n48 0.562824
R881 vss.n210 vss.t4 0.708833
R882 vss.n210 vss.t273 0.708833
R883 vss.t135 vss.n154 0.6357
R884 vss.t132 vss.t4 0.6357
R885 vss.n11 vss.n10 0.197718
R886 vss.n11 vss.t271 0.242764
R887 vss.t167 vss.n32 0.347839
R888 vss.n8 vss.t276 0.242764
R889 vss.t155 vss.n31 0.103587
R890 vss.n14 vss.t122 0.242729
R891 vss.n14 vss.n13 0.197736
R892 vss.n18 vss.t171 0.242729
R893 vss.n18 vss.n17 0.197736
R894 vss.n22 vss.t177 0.242729
R895 vss.n22 vss.n21 0.197736
R896 vss.n145 vss.n144 0.618225
R897 vss.n138 vss.n130 0.615637
R898 vss.n240 vss.n127 0.613049
R899 vss.n139 vss.n126 0.613049
R900 vss.t14 vss.n169 0.611985
R901 vss.n142 vss.n125 0.604422
R902 vss.n106 vss.n105 0.593602
R903 vss.n243 vss.n242 0.592597
R904 vss.n101 vss.n87 0.586266
R905 vss.t276 vss.t31 0.58193
R906 vss.t75 vss.t65 0.575378
R907 vss.t77 vss.t60 0.575378
R908 vss.t181 vss.t179 0.575378
R909 vss.n236 vss.n130 0.575088
R910 vss.n144 vss.n137 0.5725
R911 vss.n145 vss.n142 0.565598
R912 vss.n148 vss.n128 0.560881
R913 vss.n139 vss.n138 0.556971
R914 vss.n27 vss.n32 0.133757
R915 vss.n65 vss.n52 0.547176
R916 vss.n154 vss.n34 0.5263
R917 vss.t4 vss.n5 0.5263
R918 vss.t14 vss.n212 0.5263
R919 vss.n45 vss.n128 0.52521
R920 vss.t111 vss.t119 0.511577
R921 vss.n124 vss.n39 0.49992
R922 vss.t4 vss.t63 0.485123
R923 vss.n242 vss.n3 0.46593
R924 vss.n52 vss.n49 0.203222
R925 vss.n106 vss.n3 0.463518
R926 vss.n149 vss.n136 0.430041
R927 vss.n141 vss.n140 0.428608
R928 vss.n174 vss.n25 0.42625
R929 vss.n182 vss.n25 0.42625
R930 vss.n214 vss.n161 0.42625
R931 vss.n186 vss.n25 0.42625
R932 vss.n178 vss.n25 0.42625
R933 vss.n172 vss.n25 0.4255
R934 vss.n176 vss.n25 0.4255
R935 vss.n180 vss.n25 0.4255
R936 vss.n184 vss.n25 0.4255
R937 vss.n188 vss.n25 0.4255
R938 vss.n214 vss.n170 0.4255
R939 vss.n214 vss.n157 0.4255
R940 vss.n0 vss.n241 0.423851
R941 vss.n150 vss.n44 0.420944
R942 vss.n237 vss.n129 0.42068
R943 vss.n81 vss.n80 0.378199
R944 vss.n52 vss.n81 0.00971755
R945 vss.n48 vss.n47 0.567829
R946 vss.n66 vss.n63 0.366444
R947 vss.t58 vss.n23 0.172154
R948 vss.n63 vss.n41 0.356625
R949 vss.n210 vss.n209 0.355417
R950 vss.n62 vss.n60 0.345833
R951 vss.n60 vss.n78 0.345833
R952 vss.n110 vss.n78 0.345167
R953 vss.n111 vss.n110 0.339833
R954 vss.n37 vss.n35 0.173129
R955 vss.t18 vss.n31 0.176142
R956 vss.n154 vss.n231 0.32095
R957 vss.n231 vss.n25 0.310172
R958 vss.t31 vss.t21 0.306711
R959 vss.n215 vss.t58 0.414796
R960 vss.n40 vss.t274 0.158514
R961 vss.n3 vss.n2 0.261628
R962 vss.n112 vss.n102 0.261628
R963 vss.t120 vss.t111 0.258111
R964 vss.n61 vss.n253 0.25737
R965 vss.n120 vss.n119 0.256659
R966 vss.n250 vss.n249 0.256659
R967 vss.n76 vss.n118 0.255947
R968 vss.t380 vss.t135 0.254722
R969 vss.n117 vss.n116 0.254523
R970 vss.n75 vss.n121 0.253811
R971 vss.n64 vss.n251 0.253811
R972 vss.n252 vss.n72 0.253098
R973 vss.n123 vss.n122 0.248811
R974 vss.n53 vss.n113 0.248811
R975 vss.t148 vss.t149 0.248585
R976 vss.t145 vss.t147 0.247649
R977 vss.n58 vss.n70 0.240726
R978 vss.n141 vss.n39 0.237342
R979 vss.n3 vss.n0 0.237342
R980 vss.n129 vss.n49 0.237342
R981 vss.n143 vss.n59 0.237342
R982 vss.n74 vss.n71 0.232115
R983 vss.n82 vss.n71 0.232115
R984 vss.n214 vss.n198 0.228287
R985 vss.n50 vss.n49 0.210203
R986 vss.n242 vss.n124 0.207231
R987 vss.n111 vss.n106 0.205397
R988 vss.n74 vss.n50 0.204825
R989 vss.n81 vss.n69 0.200882
R990 vss.n62 vss.n61 0.187842
R991 vss.n66 vss.n64 0.187253
R992 vss.n120 vss.n41 0.187217
R993 vss.n74 vss.n72 0.186867
R994 vss.n70 vss.n75 0.186552
R995 vss.n78 vss.n77 0.186509
R996 vss.n74 vss.n73 0.185842
R997 vss.n108 vss.n82 0.185842
R998 vss.n124 vss.n123 0.185842
R999 vss.n114 vss.n54 0.185842
R1000 vss.n54 vss.n53 0.185842
R1001 vss.n112 vss.n111 0.185842
R1002 vss.n70 vss.n76 0.185842
R1003 vss.n117 vss.n82 0.185842
R1004 vss.n250 vss.n69 0.185842
R1005 vss.n69 vss.n68 0.185842
R1006 vss.n58 vss.n69 0.182666
R1007 vss.n38 vss.n79 0.18065
R1008 vss.n54 vss.n38 0.180341
R1009 vss.n39 vss.n38 0.179991
R1010 vss.n82 vss.n38 0.177457
R1011 vss.n151 vss.n150 0.177065
R1012 vss.n152 vss.n136 0.176861
R1013 vss.n210 vss.n199 0.173969
R1014 vss.n211 vss.n210 0.173969
R1015 vss.n210 vss.n208 0.173969
R1016 vss.n210 vss.n201 0.173969
R1017 vss.n214 vss.n195 0.1721
R1018 vss.n214 vss.n190 0.17189
R1019 vss.n60 vss.n93 0.162063
R1020 vss.n63 vss.n67 0.16
R1021 vss.n254 vss.n95 0.158224
R1022 vss.n110 vss.n79 0.15529
R1023 vss.n234 vss.n233 0.145792
R1024 vss.n59 vss.n58 0.134909
R1025 vss.n58 vss.n67 0.134562
R1026 vss.n93 vss.n71 0.133875
R1027 vss.n71 vss.n59 0.133875
R1028 vss.n232 vss.n132 0.124831
R1029 vss.t132 vss.t31 0.124556
R1030 vss.t5 vss.n205 0.1105
R1031 vss.n46 vss.n43 0.102831
R1032 vss.n149 vss.n35 1.08006
R1033 vss.n80 vss.n65 0.0764292
R1034 vss.n200 vss.n40 0.157175
R1035 vss.n151 vss.n43 0.0596475
R1036 vss.n214 vss.n169 0.0515479
R1037 vss.n46 vss.n45 0.0396332
R1038 vss.n36 vss.n43 1.5051
R1039 vss.n35 vss.t59 1.37446
R1040 vss.n8 vss.t4 1.1549
R1041 vss.n4 vss.n54 0.505494
R1042 vss.n21 vss.n34 1.07923
R1043 vss.n17 vss.n21 1.07923
R1044 vss.n13 vss.n17 1.07923
R1045 vss.n5 vss.n10 1.07923
R1046 vss.n10 vss.n27 1.07923
R1047 vss.n212 vss.t4 1.07923
R1048 vss.n21 vss.n20 1.07665
R1049 vss.n17 vss.n16 1.07665
R1050 vss.n28 vss.n10 1.07665
R1051 vss.n26 vss.n13 1.0506
R1052 vss.t58 vss.t57 1.00714
R1053 x2.outb1n.n45 x2.outb1n.n44 11.2416
R1054 x2.outb1n.n51 x2.outb1n.n28 10.1504
R1055 x2.outb1n.n50 x2.outb1n.n30 10.1504
R1056 x2.outb1n.n29 x2.outb1n.n49 10.1504
R1057 x2.outb1n.n20 x2.outb1n.n48 10.1504
R1058 x2.outb1n.n43 x2.outb1n.n15 10.1504
R1059 x2.outb1n.n19 x2.outb1n.n18 10.1504
R1060 x2.outb1n.n46 x2.outb1n.n45 10.1504
R1061 x2.outb1n.n21 x2.outb1n.n36 10.0917
R1062 x2.outb1n.n67 x2.outb1n.n25 9.7012
R1063 x2.outb1n.n44 x2.outb1n.n26 9.7012
R1064 x2.outb1n.n54 x2.outb1n.n4 9.3888
R1065 x2.outb1n.n51 x2.outb1n.n5 9.3888
R1066 x2.outb1n x2.outb1n.n69 9.03344
R1067 x2.outb1n.n53 x2.outb1n.n52 9.0005
R1068 x2.outb1n.n25 x2.outb1n.n12 9.0005
R1069 x2.outb1n.n65 x2.outb1n.n13 9.0005
R1070 x2.outb1n.n61 x2.outb1n.n14 9.0005
R1071 x2.outb1n.n60 x2.outb1n.n7 9.0005
R1072 x2.outb1n.n57 x2.outb1n.n27 9.0005
R1073 x2.outb1n.n4 x2.outb1n.n56 9.0005
R1074 x2.outb1n.n5 x2.outb1n.n50 9.0005
R1075 x2.outb1n.n34 x2.outb1n.n32 9.0005
R1076 x2.outb1n.n21 x2.outb1n.n37 9.0005
R1077 x2.outb1n.n64 x2.outb1n.n22 9.0005
R1078 x2.outb1n.n63 x2.outb1n.n62 9.0005
R1079 x2.outb1n.n24 x2.outb1n.n23 9.0005
R1080 x2.outb1n.n33 x2.outb1n.n40 9.0005
R1081 x2.outb1n.n49 x2.outb1n.n31 9.0005
R1082 x2.outb1n.n26 x2.outb1n.n46 9.0005
R1083 x2.outb1n.n16 x2.outb1n.n18 9.0005
R1084 x2.outb1n.n17 x2.outb1n.n15 9.0005
R1085 x2.outb1n.n48 x2.outb1n.n47 9.0005
R1086 x2.outb1n.n28 x2.outb1n 7.43411
R1087 x2.outb1n.n52 x2.outb1n 7.43202
R1088 x2.outb1n.n20 x2.outb1n 6.89219
R1089 x2.outb1n.n19 x2.outb1n 6.89219
R1090 x2.outb1n.n17 x2.outb1n 6.89219
R1091 x2.outb1n.n26 x2.outb1n 6.89219
R1092 x2.outb1n.n5 x2.outb1n 6.87459
R1093 x2.outb1n.n14 x2.outb1n 6.86795
R1094 x2.outb1n.n25 x2.outb1n 6.86795
R1095 x2.outb1n.n4 x2.outb1n 6.85195
R1096 x2.outb1n.n30 x2.outb1n 6.74551
R1097 x2.outb1n.n31 x2.outb1n 6.74399
R1098 x2.outb1n.n24 x2.outb1n 6.74399
R1099 x2.outb1n.n22 x2.outb1n 6.74399
R1100 x2.outb1n.n27 x2.outb1n 6.74111
R1101 x2.outb1n.n34 x2.outb1n 6.7364
R1102 x2.outb1n.n0 x2.outb1n.n41 5.78895
R1103 x2.outb1n x2.outb1n.t47 5.66717
R1104 x2.outb1n x2.outb1n.t35 5.66717
R1105 x2.outb1n x2.outb1n.t46 5.66717
R1106 x2.outb1n x2.outb1n.t34 5.66717
R1107 x2.outb1n x2.outb1n.t45 5.66717
R1108 x2.outb1n x2.outb1n.t33 5.66717
R1109 x2.outb1n x2.outb1n.t44 5.66717
R1110 x2.outb1n x2.outb1n.t32 5.66717
R1111 x2.outb1n x2.outb1n.t43 5.66717
R1112 x2.outb1n x2.outb1n.t31 5.66717
R1113 x2.outb1n x2.outb1n.t41 5.66717
R1114 x2.outb1n x2.outb1n.t29 5.66717
R1115 x2.outb1n x2.outb1n.t42 5.66717
R1116 x2.outb1n x2.outb1n.t30 5.66717
R1117 x2.outb1n x2.outb1n.t38 5.66717
R1118 x2.outb1n x2.outb1n.t26 5.66717
R1119 x2.outb1n x2.outb1n.t40 5.66717
R1120 x2.outb1n x2.outb1n.t28 5.66717
R1121 x2.outb1n x2.outb1n.t39 5.66717
R1122 x2.outb1n x2.outb1n.t27 5.66717
R1123 x2.outb1n x2.outb1n.t37 5.66717
R1124 x2.outb1n x2.outb1n.t25 5.66717
R1125 x2.outb1n x2.outb1n.t36 5.66717
R1126 x2.outb1n x2.outb1n.t24 5.66717
R1127 x2.outb1n.n41 x2.outb1n 5.2792
R1128 x2.outb1n.n42 x2.outb1n 5.2792
R1129 x2.outb1n.n55 x2.outb1n 5.2792
R1130 x2.outb1n.n39 x2.outb1n 5.2792
R1131 x2.outb1n.n58 x2.outb1n 5.2792
R1132 x2.outb1n.n59 x2.outb1n 5.2792
R1133 x2.outb1n.n6 x2.outb1n 5.2792
R1134 x2.outb1n.n11 x2.outb1n 5.2792
R1135 x2.outb1n.n38 x2.outb1n 5.2792
R1136 x2.outb1n.n66 x2.outb1n 5.2792
R1137 x2.outb1n.n35 x2.outb1n 5.2792
R1138 x2.outb1n.n68 x2.outb1n 5.2792
R1139 x2.outb1n.n56 x2.outb1n.n0 5.17457
R1140 x2.outb1n x2.outb1n.n10 5.1683
R1141 x2.outb1n.n70 x2.outb1n 5.06875
R1142 x2.outb1n.n0 x2.outb1n.n42 5.06582
R1143 x2.outb1n.n0 x2.outb1n.n55 5.06582
R1144 x2.outb1n.n0 x2.outb1n.n39 5.06582
R1145 x2.outb1n.n1 x2.outb1n.n58 5.06582
R1146 x2.outb1n.n1 x2.outb1n.n59 5.06582
R1147 x2.outb1n.n2 x2.outb1n.n38 5.06582
R1148 x2.outb1n.n2 x2.outb1n.n66 5.06582
R1149 x2.outb1n.n3 x2.outb1n.n35 5.06582
R1150 x2.outb1n.n69 x2.outb1n.n68 5.06582
R1151 x2.outb1n.n2 x2.outb1n.n65 5.03791
R1152 x2.outb1n.n3 x2.outb1n.n67 5.03573
R1153 x2.outb1n.n61 x2.outb1n.n1 5.03414
R1154 x2.outb1n.n1 x2.outb1n.n57 5.03204
R1155 x2.outb1n.n0 x2.outb1n.n54 5.01388
R1156 x2.outb1n.n12 x2.outb1n.n3 4.5005
R1157 x2.outb1n.n7 x2.outb1n.n1 4.5005
R1158 x2.outb1n.n41 x2.outb1n 4.5005
R1159 x2.outb1n.n42 x2.outb1n 4.5005
R1160 x2.outb1n.n55 x2.outb1n 4.5005
R1161 x2.outb1n.n39 x2.outb1n 4.5005
R1162 x2.outb1n.n58 x2.outb1n 4.5005
R1163 x2.outb1n.n59 x2.outb1n 4.5005
R1164 x2.outb1n.n6 x2.outb1n 4.5005
R1165 x2.outb1n.n11 x2.outb1n 4.5005
R1166 x2.outb1n.n38 x2.outb1n 4.5005
R1167 x2.outb1n.n66 x2.outb1n 4.5005
R1168 x2.outb1n.n35 x2.outb1n 4.5005
R1169 x2.outb1n.n68 x2.outb1n 4.5005
R1170 x2.outb1n.n9 x2.outb1n 4.09775
R1171 x2.outb1n.n8 x2.outb1n 4.0777
R1172 x2.outb1n.n10 x2.outb1n 3.58589
R1173 x2.outb1n.n10 x2.outb1n 3.58589
R1174 x2.outb1n.n9 x2.outb1n 3.58203
R1175 x2.outb1n x2.outb1n.n70 3.55243
R1176 x2.outb1n.n8 x2.outb1n 3.55243
R1177 x2.outb1n.n8 x2.outb1n 3.5453
R1178 x2.outb1n x2.outb1n.t3 2.83383
R1179 x2.outb1n x2.outb1n.t2 2.83383
R1180 x2.outb1n x2.outb1n.t1 2.83383
R1181 x2.outb1n x2.outb1n.t0 2.83383
R1182 x2.outb1n x2.outb1n.t7 2.83383
R1183 x2.outb1n x2.outb1n.t6 2.83383
R1184 x2.outb1n x2.outb1n.t5 2.83383
R1185 x2.outb1n x2.outb1n.t4 2.83383
R1186 x2.outb1n x2.outb1n.t11 2.83383
R1187 x2.outb1n x2.outb1n.t10 2.83383
R1188 x2.outb1n x2.outb1n.t9 2.83383
R1189 x2.outb1n x2.outb1n.t8 2.83383
R1190 x2.outb1n x2.outb1n.t15 2.83383
R1191 x2.outb1n x2.outb1n.t14 2.83383
R1192 x2.outb1n x2.outb1n.t13 2.83383
R1193 x2.outb1n x2.outb1n.t12 2.83383
R1194 x2.outb1n.n1 x2.outb1n.n0 2.16989
R1195 x2.outb1n.n1 x2.outb1n.n2 2.16989
R1196 x2.outb1n.n5 x2.outb1n.n31 1.7638
R1197 x2.outb1n.n27 x2.outb1n.n4 1.7638
R1198 x2.outb1n x2.outb1n.t23 1.54595
R1199 x2.outb1n x2.outb1n.t20 1.54595
R1200 x2.outb1n x2.outb1n.t21 1.54595
R1201 x2.outb1n x2.outb1n.t22 1.54595
R1202 x2.outb1n x2.outb1n.t16 1.54595
R1203 x2.outb1n x2.outb1n.t17 1.54595
R1204 x2.outb1n x2.outb1n.t18 1.54595
R1205 x2.outb1n x2.outb1n.t19 1.54595
R1206 x2.outb1n.n16 x2.outb1n.n26 1.4822
R1207 x2.outb1n.n25 x2.outb1n.n13 1.4822
R1208 x2.outb1n.n3 x2.outb1n.n2 1.47641
R1209 x2.outb1n.n69 x2.outb1n.n3 1.41711
R1210 x2.outb1n.n54 x2.outb1n.n53 1.15037
R1211 x2.outb1n.n53 x2.outb1n.n51 1.15037
R1212 x2.outb1n.n56 x2.outb1n.n32 1.15037
R1213 x2.outb1n.n50 x2.outb1n.n32 1.15037
R1214 x2.outb1n.n57 x2.outb1n.n40 1.15037
R1215 x2.outb1n.n49 x2.outb1n.n40 1.15037
R1216 x2.outb1n.n7 x2.outb1n.n23 1.15037
R1217 x2.outb1n.n48 x2.outb1n.n23 1.15037
R1218 x2.outb1n.n62 x2.outb1n.n61 1.15037
R1219 x2.outb1n.n62 x2.outb1n.n15 1.15037
R1220 x2.outb1n.n65 x2.outb1n.n64 1.15037
R1221 x2.outb1n.n64 x2.outb1n.n18 1.15037
R1222 x2.outb1n.n12 x2.outb1n.n37 1.15037
R1223 x2.outb1n.n46 x2.outb1n.n37 1.15037
R1224 x2.outb1n.n67 x2.outb1n.n36 1.15037
R1225 x2.outb1n.n44 x2.outb1n.n36 1.15037
R1226 x2.outb1n.n7 x2.outb1n.n6 1.14738
R1227 x2.outb1n.n22 x2.outb1n.n21 1.0917
R1228 x2.outb1n.n45 x2.outb1n.n19 1.0917
R1229 x2.outb1n.n14 x2.outb1n.n60 1.0763
R1230 x2.outb1n.n22 x2.outb1n.n63 1.0763
R1231 x2.outb1n.n33 x2.outb1n.n24 1.0763
R1232 x2.outb1n.n52 x2.outb1n.n34 1.0763
R1233 x2.outb1n.n47 x2.outb1n.n17 1.0763
R1234 x2.outb1n.n19 x2.outb1n.n43 1.0763
R1235 x2.outb1n.n29 x2.outb1n.n20 1.0763
R1236 x2.outb1n.n30 x2.outb1n.n28 1.0763
R1237 x2.outb1n.n34 x2.outb1n.n33 1.0763
R1238 x2.outb1n.n47 x2.outb1n.n31 1.0763
R1239 x2.outb1n.n30 x2.outb1n.n29 1.0763
R1240 x2.outb1n.n60 x2.outb1n.n27 1.0763
R1241 x2.outb1n.n63 x2.outb1n.n24 1.0763
R1242 x2.outb1n.n43 x2.outb1n.n20 1.0763
R1243 x2.outb1n.n17 x2.outb1n.n16 1.0763
R1244 x2.outb1n.n14 x2.outb1n.n13 1.0763
R1245 x2.outb1n.n12 x2.outb1n.n11 1.07463
R1246 x2.outb1n.n10 x2.outb1n.n9 1.04695
R1247 x2.outb1n.n70 x2.outb1n.n8 1.04422
R1248 x2.outb1p.n41 x2.outb1p.n30 10.743
R1249 x2.outb1p.n54 x2.outb1p.n8 10.6619
R1250 x2.outb1p.n52 x2.outb1p.n8 10.1504
R1251 x2.outb1p.n20 x2.outb1p.n51 10.1504
R1252 x2.outb1p.n49 x2.outb1p.n48 10.1504
R1253 x2.outb1p.n19 x2.outb1p.n47 10.1504
R1254 x2.outb1p.n45 x2.outb1p.n44 10.1504
R1255 x2.outb1p.n30 x2.outb1p.n43 10.1504
R1256 x2.outb1p.n42 x2.outb1p.n41 10.0917
R1257 x2.outb1p.n67 x2.outb1p.n66 10.0917
R1258 x2.outb1p.n33 x2.outb1p.n31 9.5956
R1259 x2.outb1p.n55 x2.outb1p.n10 9.512
R1260 x2.outb1p.n58 x2.outb1p.n57 9.0005
R1261 x2.outb1p.n54 x2.outb1p.n53 9.0005
R1262 x2.outb1p.n6 x2.outb1p.n16 9.0005
R1263 x2.outb1p.n10 x2.outb1p.n9 9.0005
R1264 x2.outb1p.n29 x2.outb1p.n52 9.0005
R1265 x2.outb1p.n43 x2.outb1p.n42 9.0005
R1266 x2.outb1p.n27 x2.outb1p.n45 9.0005
R1267 x2.outb1p.n47 x2.outb1p.n46 9.0005
R1268 x2.outb1p.n28 x2.outb1p.n49 9.0005
R1269 x2.outb1p.n51 x2.outb1p.n50 9.0005
R1270 x2.outb1p.n59 x2.outb1p.n3 9.0005
R1271 x2.outb1p.n26 x2.outb1p.n24 9.0005
R1272 x2.outb1p.n33 x2.outb1p.n32 9.0005
R1273 x2.outb1p.n22 x2.outb1p.n37 9.0005
R1274 x2.outb1p.n23 x2.outb1p.n21 9.0005
R1275 x2.outb1p.n25 x2.outb1p.n39 9.0005
R1276 x2.outb1p.n60 x2.outb1p.n15 9.0005
R1277 x2.outb1p.n66 x2.outb1p.n65 9.0005
R1278 x2.outb1p.n12 x2.outb1p.n14 9.0005
R1279 x2.outb1p.n63 x2.outb1p.n62 9.0005
R1280 x2.outb1p x2.outb1p.n70 8.00759
R1281 x2.outb1p.n58 x2.outb1p 7.03397
R1282 x2.outb1p.n53 x2.outb1p 6.96826
R1283 x2.outb1p.n16 x2.outb1p 6.47627
R1284 x2.outb1p.n10 x2.outb1p 6.47157
R1285 x2.outb1p.n26 x2.outb1p 6.47157
R1286 x2.outb1p.n8 x2.outb1p 6.46497
R1287 x2.outb1p.n20 x2.outb1p 6.46497
R1288 x2.outb1p.n28 x2.outb1p 6.39808
R1289 x2.outb1p.n27 x2.outb1p 6.39808
R1290 x2.outb1p.n23 x2.outb1p 6.39698
R1291 x2.outb1p.n33 x2.outb1p 6.39698
R1292 x2.outb1p.n29 x2.outb1p 6.39626
R1293 x2.outb1p.n15 x2.outb1p 6.39173
R1294 x2.outb1p.n14 x2.outb1p 6.39173
R1295 x2.outb1p.n19 x2.outb1p 6.39038
R1296 x2.outb1p.n30 x2.outb1p 6.39038
R1297 x2.outb1p.n0 x2.outb1p.n56 5.74217
R1298 x2.outb1p x2.outb1p.n34 5.70952
R1299 x2.outb1p x2.outb1p.t47 5.66717
R1300 x2.outb1p x2.outb1p.t35 5.66717
R1301 x2.outb1p x2.outb1p.t46 5.66717
R1302 x2.outb1p x2.outb1p.t34 5.66717
R1303 x2.outb1p x2.outb1p.t43 5.66717
R1304 x2.outb1p x2.outb1p.t31 5.66717
R1305 x2.outb1p x2.outb1p.t42 5.66717
R1306 x2.outb1p x2.outb1p.t30 5.66717
R1307 x2.outb1p x2.outb1p.t45 5.66717
R1308 x2.outb1p x2.outb1p.t33 5.66717
R1309 x2.outb1p x2.outb1p.t44 5.66717
R1310 x2.outb1p x2.outb1p.t32 5.66717
R1311 x2.outb1p x2.outb1p.t40 5.66717
R1312 x2.outb1p x2.outb1p.t28 5.66717
R1313 x2.outb1p x2.outb1p.t41 5.66717
R1314 x2.outb1p x2.outb1p.t29 5.66717
R1315 x2.outb1p x2.outb1p.t39 5.66717
R1316 x2.outb1p x2.outb1p.t27 5.66717
R1317 x2.outb1p x2.outb1p.t38 5.66717
R1318 x2.outb1p x2.outb1p.t26 5.66717
R1319 x2.outb1p x2.outb1p.t37 5.66717
R1320 x2.outb1p x2.outb1p.t25 5.66717
R1321 x2.outb1p x2.outb1p.t36 5.66717
R1322 x2.outb1p x2.outb1p.t24 5.66717
R1323 x2.outb1p.n4 x2.outb1p.n36 5.50893
R1324 x2.outb1p.n18 x2.outb1p 5.5068
R1325 x2.outb1p.n0 x2.outb1p.n40 5.35286
R1326 x2.outb1p.n1 x2.outb1p.n38 5.35286
R1327 x2.outb1p.n4 x2.outb1p.n61 5.35286
R1328 x2.outb1p.n7 x2.outb1p.n64 5.35286
R1329 x2.outb1p.n7 x2.outb1p.n35 5.35286
R1330 x2.outb1p.n7 x2.outb1p.n68 5.35286
R1331 x2.outb1p.n70 x2.outb1p.n69 5.35286
R1332 x2.outb1p.n56 x2.outb1p 5.2792
R1333 x2.outb1p.n40 x2.outb1p 5.2792
R1334 x2.outb1p.n38 x2.outb1p 5.2792
R1335 x2.outb1p.n61 x2.outb1p 5.2792
R1336 x2.outb1p.n5 x2.outb1p 5.2792
R1337 x2.outb1p.n2 x2.outb1p 5.2792
R1338 x2.outb1p.n11 x2.outb1p 5.2792
R1339 x2.outb1p.n36 x2.outb1p 5.2792
R1340 x2.outb1p.n64 x2.outb1p 5.2792
R1341 x2.outb1p.n35 x2.outb1p 5.2792
R1342 x2.outb1p.n68 x2.outb1p 5.2792
R1343 x2.outb1p.n69 x2.outb1p 5.2792
R1344 x2.outb1p.n62 x2.outb1p.n4 5.0319
R1345 x2.outb1p.n65 x2.outb1p.n7 5.02647
R1346 x2.outb1p.n57 x2.outb1p.n0 5.02632
R1347 x2.outb1p.n1 x2.outb1p.n60 5.02603
R1348 x2.outb1p.n7 x2.outb1p.n67 5.0248
R1349 x2.outb1p.n4 x2.outb1p.n12 4.5005
R1350 x2.outb1p.n3 x2.outb1p.n1 4.5005
R1351 x2.outb1p.n1 x2.outb1p.n6 4.5005
R1352 x2.outb1p.n56 x2.outb1p 4.5005
R1353 x2.outb1p.n40 x2.outb1p 4.5005
R1354 x2.outb1p.n38 x2.outb1p 4.5005
R1355 x2.outb1p.n61 x2.outb1p 4.5005
R1356 x2.outb1p.n5 x2.outb1p 4.5005
R1357 x2.outb1p.n2 x2.outb1p 4.5005
R1358 x2.outb1p.n11 x2.outb1p 4.5005
R1359 x2.outb1p.n36 x2.outb1p 4.5005
R1360 x2.outb1p.n64 x2.outb1p 4.5005
R1361 x2.outb1p.n35 x2.outb1p 4.5005
R1362 x2.outb1p.n68 x2.outb1p 4.5005
R1363 x2.outb1p.n69 x2.outb1p 4.5005
R1364 x2.outb1p.n17 x2.outb1p 4.10459
R1365 x2.outb1p.n13 x2.outb1p 4.09864
R1366 x2.outb1p x2.outb1p.n18 3.60493
R1367 x2.outb1p.n18 x2.outb1p 3.60493
R1368 x2.outb1p.n17 x2.outb1p 3.58887
R1369 x2.outb1p.n34 x2.outb1p 3.57337
R1370 x2.outb1p.n13 x2.outb1p 3.57337
R1371 x2.outb1p.n13 x2.outb1p 3.55543
R1372 x2.outb1p x2.outb1p.t11 2.83383
R1373 x2.outb1p x2.outb1p.t15 2.83383
R1374 x2.outb1p x2.outb1p.t14 2.83383
R1375 x2.outb1p x2.outb1p.t19 2.83383
R1376 x2.outb1p x2.outb1p.t18 2.83383
R1377 x2.outb1p x2.outb1p.t17 2.83383
R1378 x2.outb1p x2.outb1p.t23 2.83383
R1379 x2.outb1p x2.outb1p.t22 2.83383
R1380 x2.outb1p x2.outb1p.t21 2.83383
R1381 x2.outb1p x2.outb1p.t20 2.83383
R1382 x2.outb1p x2.outb1p.t16 2.83383
R1383 x2.outb1p x2.outb1p.t13 2.83383
R1384 x2.outb1p x2.outb1p.t12 2.83383
R1385 x2.outb1p x2.outb1p.t10 2.83383
R1386 x2.outb1p x2.outb1p.t9 2.83383
R1387 x2.outb1p x2.outb1p.t8 2.83383
R1388 x2.outb1p.n4 x2.outb1p.n1 2.16415
R1389 x2.outb1p.n7 x2.outb1p.n4 2.11633
R1390 x2.outb1p.n1 x2.outb1p.n0 1.83989
R1391 x2.outb1p.n3 x2.outb1p.n2 1.74519
R1392 x2.outb1p.n6 x2.outb1p.n5 1.64699
R1393 x2.outb1p.n10 x2.outb1p.n26 1.6406
R1394 x2.outb1p.n8 x2.outb1p.n20 1.6406
R1395 x2.outb1p.n22 x2.outb1p.n33 1.5878
R1396 x2.outb1p.n44 x2.outb1p.n30 1.5878
R1397 x2.outb1p x2.outb1p.t7 1.54595
R1398 x2.outb1p x2.outb1p.t4 1.54595
R1399 x2.outb1p x2.outb1p.t5 1.54595
R1400 x2.outb1p x2.outb1p.t6 1.54595
R1401 x2.outb1p x2.outb1p.t3 1.54595
R1402 x2.outb1p x2.outb1p.t2 1.54595
R1403 x2.outb1p x2.outb1p.t1 1.54595
R1404 x2.outb1p x2.outb1p.t0 1.54595
R1405 x2.outb1p.n70 x2.outb1p.n7 1.44676
R1406 x2.outb1p.n12 x2.outb1p.n11 1.3899
R1407 x2.outb1p.n57 x2.outb1p.n55 1.15037
R1408 x2.outb1p.n55 x2.outb1p.n54 1.15037
R1409 x2.outb1p.n6 x2.outb1p.n9 1.15037
R1410 x2.outb1p.n52 x2.outb1p.n9 1.15037
R1411 x2.outb1p.n3 x2.outb1p.n24 1.15037
R1412 x2.outb1p.n51 x2.outb1p.n24 1.15037
R1413 x2.outb1p.n60 x2.outb1p.n39 1.15037
R1414 x2.outb1p.n49 x2.outb1p.n39 1.15037
R1415 x2.outb1p.n62 x2.outb1p.n21 1.15037
R1416 x2.outb1p.n47 x2.outb1p.n21 1.15037
R1417 x2.outb1p.n12 x2.outb1p.n37 1.15037
R1418 x2.outb1p.n45 x2.outb1p.n37 1.15037
R1419 x2.outb1p.n65 x2.outb1p.n32 1.15037
R1420 x2.outb1p.n43 x2.outb1p.n32 1.15037
R1421 x2.outb1p.n67 x2.outb1p.n31 1.1479
R1422 x2.outb1p.n41 x2.outb1p.n31 1.1479
R1423 x2.outb1p.n42 x2.outb1p.n27 1.0917
R1424 x2.outb1p.n66 x2.outb1p.n14 1.0917
R1425 x2.outb1p.n48 x2.outb1p.n19 1.0763
R1426 x2.outb1p.n46 x2.outb1p.n27 1.0763
R1427 x2.outb1p.n50 x2.outb1p.n28 1.0763
R1428 x2.outb1p.n53 x2.outb1p.n29 1.0763
R1429 x2.outb1p.n25 x2.outb1p.n23 1.0763
R1430 x2.outb1p.n14 x2.outb1p.n63 1.0763
R1431 x2.outb1p.n15 x2.outb1p.n59 1.0763
R1432 x2.outb1p.n16 x2.outb1p.n58 1.0763
R1433 x2.outb1p.n50 x2.outb1p.n29 1.0763
R1434 x2.outb1p.n46 x2.outb1p.n28 1.0763
R1435 x2.outb1p.n26 x2.outb1p.n25 1.0763
R1436 x2.outb1p.n23 x2.outb1p.n22 1.0763
R1437 x2.outb1p.n48 x2.outb1p.n20 1.0763
R1438 x2.outb1p.n44 x2.outb1p.n19 1.0763
R1439 x2.outb1p.n59 x2.outb1p.n16 1.0763
R1440 x2.outb1p.n63 x2.outb1p.n15 1.0763
R1441 x2.outb1p.n18 x2.outb1p.n17 1.04695
R1442 x2.outb1p.n34 x2.outb1p.n13 1.04422
R1443 x2.outa1p.n55 x2.outa1p.n23 10.7892
R1444 x2.outa1p.n9 x2.outa1p.n57 10.7817
R1445 x2.outa1p.n4 x2.outa1p 10.613
R1446 x2.outa1p.n44 x2.outa1p 10.4604
R1447 x2.outa1p.n50 x2.outa1p 10.4223
R1448 x2.outa1p.n23 x2.outa1p.n8 10.0052
R1449 x2.outa1p.n10 x2.outa1p.n9 10.0011
R1450 x2.outa1p.n4 x2.outa1p 9.84537
R1451 x2.outa1p.n5 x2.outa1p 9.84537
R1452 x2.outa1p.n5 x2.outa1p 9.84537
R1453 x2.outa1p.n5 x2.outa1p 9.84235
R1454 x2.outa1p.n20 x2.outa1p 9.83983
R1455 x2.outa1p.n20 x2.outa1p 9.83657
R1456 x2.outa1p.n7 x2.outa1p 9.83657
R1457 x2.outa1p.n28 x2.outa1p.n49 9.55417
R1458 x2.outa1p.n34 x2.outa1p.n33 9.4977
R1459 x2.outa1p.n40 x2.outa1p 9.23584
R1460 x2.outa1p.n49 x2.outa1p 9.22825
R1461 x2.outa1p.n21 x2.outa1p 9.22371
R1462 x2.outa1p.n8 x2.outa1p 9.22294
R1463 x2.outa1p.n10 x2.outa1p 9.21839
R1464 x2.outa1p.n11 x2.outa1p 9.20897
R1465 x2.outa1p.n13 x2.outa1p 9.20588
R1466 x2.outa1p.n19 x2.outa1p 9.20332
R1467 x2.outa1p.n16 x2.outa1p 9.20102
R1468 x2.outa1p.n42 x2.outa1p 9.19995
R1469 x2.outa1p.n15 x2.outa1p 9.19814
R1470 x2.outa1p.n33 x2.outa1p 9.19355
R1471 x2.outa1p.n39 x2.outa1p 9.19127
R1472 x2.outa1p.n41 x2.outa1p 9.18939
R1473 x2.outa1p.n51 x2.outa1p.n25 9.0005
R1474 x2.outa1p.n40 x2.outa1p.n25 9.0005
R1475 x2.outa1p.n48 x2.outa1p.n26 9.0005
R1476 x2.outa1p.n26 x2.outa1p.n41 9.0005
R1477 x2.outa1p.n52 x2.outa1p.n32 9.0005
R1478 x2.outa1p.n39 x2.outa1p.n27 9.0005
R1479 x2.outa1p.n47 x2.outa1p.n27 9.0005
R1480 x2.outa1p.n32 x2.outa1p.n42 9.0005
R1481 x2.outa1p.n53 x2.outa1p.n29 9.0005
R1482 x2.outa1p.n30 x2.outa1p.n15 9.0005
R1483 x2.outa1p.n34 x2.outa1p.n50 9.0005
R1484 x2.outa1p.n44 x2.outa1p.n28 9.0005
R1485 x2.outa1p.n22 x2.outa1p.n21 9.0005
R1486 x2.outa1p.n31 x2.outa1p.n46 9.0005
R1487 x2.outa1p.n13 x2.outa1p.n12 9.0005
R1488 x2.outa1p.n57 x2.outa1p.n6 9.0005
R1489 x2.outa1p.n24 x2.outa1p.n10 9.0005
R1490 x2.outa1p.n56 x2.outa1p.n12 9.0005
R1491 x2.outa1p.n31 x2.outa1p.n16 9.0005
R1492 x2.outa1p.n45 x2.outa1p.n22 9.0005
R1493 x2.outa1p.n29 x2.outa1p.n19 9.0005
R1494 x2.outa1p.n30 x2.outa1p.n18 9.0005
R1495 x2.outa1p.n3 x2.outa1p.n11 9.0005
R1496 x2.outa1p.n55 x2.outa1p.n24 9.0005
R1497 x2.outa1p.n8 x2.outa1p.n54 9.0005
R1498 x2.outa1p.n14 x2.outa1p.n3 9.0005
R1499 x2.outa1p.n37 x2.outa1p 7.05745
R1500 x2.outa1p.n35 x2.outa1p 7.04865
R1501 x2.outa1p.n38 x2.outa1p 6.46785
R1502 x2.outa1p.n38 x2.outa1p 6.46785
R1503 x2.outa1p.n37 x2.outa1p 6.46345
R1504 x2.outa1p.n35 x2.outa1p 6.45465
R1505 x2.outa1p x2.outa1p.n36 6.45025
R1506 x2.outa1p.n36 x2.outa1p 6.45025
R1507 x2.outa1p x2.outa1p.n38 5.98964
R1508 x2.outa1p.n1 x2.outa1p.n34 5.8967
R1509 x2.outa1p.n36 x2.outa1p 5.71101
R1510 x2.outa1p x2.outa1p.t19 5.66717
R1511 x2.outa1p x2.outa1p.t23 5.66717
R1512 x2.outa1p x2.outa1p.t22 5.66717
R1513 x2.outa1p x2.outa1p.t35 5.66717
R1514 x2.outa1p x2.outa1p.t8 5.66717
R1515 x2.outa1p x2.outa1p.t29 5.66717
R1516 x2.outa1p x2.outa1p.t28 5.66717
R1517 x2.outa1p x2.outa1p.t24 5.66717
R1518 x2.outa1p x2.outa1p.t27 5.66717
R1519 x2.outa1p x2.outa1p.t26 5.66717
R1520 x2.outa1p x2.outa1p.t25 5.66717
R1521 x2.outa1p x2.outa1p.t21 5.66717
R1522 x2.outa1p x2.outa1p.t20 5.66717
R1523 x2.outa1p x2.outa1p.t16 5.66717
R1524 x2.outa1p x2.outa1p.t17 5.66717
R1525 x2.outa1p x2.outa1p.t18 5.66717
R1526 x2.outa1p x2.outa1p.t31 5.66717
R1527 x2.outa1p x2.outa1p.t30 5.66717
R1528 x2.outa1p x2.outa1p.t15 5.66717
R1529 x2.outa1p x2.outa1p.t10 5.66717
R1530 x2.outa1p x2.outa1p.t34 5.66717
R1531 x2.outa1p x2.outa1p.t33 5.66717
R1532 x2.outa1p x2.outa1p.t13 5.66717
R1533 x2.outa1p x2.outa1p.t12 5.66717
R1534 x2.outa1p x2.outa1p.t9 5.66717
R1535 x2.outa1p x2.outa1p.t32 5.66717
R1536 x2.outa1p x2.outa1p.t14 5.66717
R1537 x2.outa1p x2.outa1p.t11 5.66717
R1538 x2.outa1p.n43 x2.outa1p 5.54445
R1539 x2.outa1p.n6 x2.outa1p 5.37194
R1540 x2.outa1p.n22 x2.outa1p 5.33657
R1541 x2.outa1p.n27 x2.outa1p.n5 5.18401
R1542 x2.outa1p.n26 x2.outa1p.n5 5.18228
R1543 x2.outa1p.n7 x2.outa1p.n12 5.14941
R1544 x2.outa1p x2.outa1p.n9 5.1476
R1545 x2.outa1p.n20 x2.outa1p.n31 5.14169
R1546 x2.outa1p.n32 x2.outa1p.n1 5.03099
R1547 x2.outa1p.n23 x2.outa1p.n2 4.99075
R1548 x2.outa1p.n54 x2.outa1p.n2 4.98977
R1549 x2.outa1p.n0 x2.outa1p.n3 4.98361
R1550 x2.outa1p.n0 x2.outa1p.n30 4.97853
R1551 x2.outa1p.n25 x2.outa1p.n1 4.96314
R1552 x2.outa1p.n29 x2.outa1p.n0 4.96258
R1553 x2.outa1p.n7 x2.outa1p.n6 4.5185
R1554 x2.outa1p.n17 x2.outa1p.n22 4.5005
R1555 x2.outa1p.n4 x2.outa1p.n43 4.5005
R1556 x2.outa1p x2.outa1p.t7 2.83383
R1557 x2.outa1p x2.outa1p.t6 2.83383
R1558 x2.outa1p x2.outa1p.t5 2.83383
R1559 x2.outa1p x2.outa1p.t4 2.83383
R1560 x2.outa1p x2.outa1p.t3 2.83383
R1561 x2.outa1p x2.outa1p.t2 2.83383
R1562 x2.outa1p x2.outa1p.t1 2.83383
R1563 x2.outa1p x2.outa1p.t0 2.83383
R1564 x2.outa1p.n2 x2.outa1p.n0 2.83276
R1565 x2.outa1p.n29 x2.outa1p.n22 2.67867
R1566 x2.outa1p.n8 x2.outa1p.n14 2.58183
R1567 x2.outa1p.n10 x2.outa1p.n56 2.56956
R1568 x2.outa1p.n5 x2.outa1p.n17 2.3765
R1569 x2.outa1p x2.outa1p.n2 2.10867
R1570 x2.outa1p.n23 x2.outa1p.n9 2.01932
R1571 x2.outa1p.n12 x2.outa1p.n3 1.98772
R1572 x2.outa1p.n26 x2.outa1p.n25 1.97118
R1573 x2.outa1p.n32 x2.outa1p.n27 1.96634
R1574 x2.outa1p.n31 x2.outa1p.n30 1.96214
R1575 x2.outa1p.n1 x2.outa1p.n0 1.89059
R1576 x2.outa1p.n15 x2.outa1p.n53 1.87233
R1577 x2.outa1p.n19 x2.outa1p.n52 1.8705
R1578 x2.outa1p.n19 x2.outa1p.n18 1.87021
R1579 x2.outa1p.n16 x2.outa1p.n45 1.86824
R1580 x2.outa1p.n47 x2.outa1p.n21 1.86625
R1581 x2.outa1p.n45 x2.outa1p.n39 1.86526
R1582 x2.outa1p.n46 x2.outa1p.n21 1.8643
R1583 x2.outa1p.n42 x2.outa1p.n51 1.81183
R1584 x2.outa1p.n53 x2.outa1p.n42 1.81183
R1585 x2.outa1p.n48 x2.outa1p.n39 1.79717
R1586 x2.outa1p.n52 x2.outa1p.n40 1.79717
R1587 x2.outa1p.n50 x2.outa1p.n40 1.78983
R1588 x2.outa1p.n11 x2.outa1p.n18 1.78925
R1589 x2.outa1p.n41 x2.outa1p.n44 1.78558
R1590 x2.outa1p.n56 x2.outa1p.n16 1.78532
R1591 x2.outa1p.n11 x2.outa1p.n55 1.78401
R1592 x2.outa1p.n15 x2.outa1p.n14 1.78323
R1593 x2.outa1p.n57 x2.outa1p.n13 1.78169
R1594 x2.outa1p.n46 x2.outa1p.n13 1.78169
R1595 x2.outa1p.n41 x2.outa1p.n47 1.77782
R1596 x2.outa1p.n20 x2.outa1p.n7 1.65679
R1597 x2.outa1p.n5 x2.outa1p.n4 1.5845
R1598 x2.outa1p.n17 x2.outa1p.n20 1.51221
R1599 x2.outa1p.n43 x2.outa1p.n28 1.41682
R1600 x2.outa1p.n54 x2.outa1p.n24 1.34638
R1601 x2.outa1p.n6 x2.outa1p.n24 1.32179
R1602 x2.outa1p.n34 x2.outa1p.n28 1.29868
R1603 x2.outa1p.n51 x2.outa1p.n33 1.2677
R1604 x2.outa1p.n49 x2.outa1p.n48 1.23617
R1605 x2.outa1p.n7 x2.outa1p 1.22726
R1606 x2.outa1p.n38 x2.outa1p.n37 1.19479
R1607 x2.outa1p.n36 x2.outa1p.n35 1.19479
R1608 x2.outa1n.n78 x2.outa1n.n16 10.7752
R1609 x2.outa1n.n17 x2.outa1n.n80 10.773
R1610 x2.outa1n.n92 x2.outa1n 10.4589
R1611 x2.outa1n.n88 x2.outa1n 10.4554
R1612 x2.outa1n.n14 x2.outa1n.n87 10.2399
R1613 x2.outa1n.n81 x2.outa1n.n34 10.1927
R1614 x2.outa1n.n17 x2.outa1n.n31 10.1859
R1615 x2.outa1n.n90 x2.outa1n.n14 9.56041
R1616 x2.outa1n.n28 x2.outa1n 9.2853
R1617 x2.outa1n.n18 x2.outa1n 9.24569
R1618 x2.outa1n.n41 x2.outa1n 9.22266
R1619 x2.outa1n.n90 x2.outa1n 9.22252
R1620 x2.outa1n.n87 x2.outa1n 9.21952
R1621 x2.outa1n.n27 x2.outa1n 9.21899
R1622 x2.outa1n.n4 x2.outa1n 9.21834
R1623 x2.outa1n.n36 x2.outa1n 9.21653
R1624 x2.outa1n.n39 x2.outa1n 9.21626
R1625 x2.outa1n.n5 x2.outa1n 9.21545
R1626 x2.outa1n.n35 x2.outa1n 9.21401
R1627 x2.outa1n.n34 x2.outa1n 9.21053
R1628 x2.outa1n.n31 x2.outa1n 9.20983
R1629 x2.outa1n.n25 x2.outa1n 9.20728
R1630 x2.outa1n.n25 x2.outa1n.n13 9.01131
R1631 x2.outa1n.n44 x2.outa1n.n78 9.0005
R1632 x2.outa1n.n31 x2.outa1n.n79 9.0005
R1633 x2.outa1n.n80 x2.outa1n.n20 9.0005
R1634 x2.outa1n.n34 x2.outa1n.n20 9.0005
R1635 x2.outa1n.n21 x2.outa1n.n82 9.0005
R1636 x2.outa1n.n19 x2.outa1n.n18 9.0005
R1637 x2.outa1n.n86 x2.outa1n.n15 9.0005
R1638 x2.outa1n.n35 x2.outa1n.n11 9.0005
R1639 x2.outa1n.n85 x2.outa1n.n84 9.0005
R1640 x2.outa1n.n24 x2.outa1n.n5 9.0005
R1641 x2.outa1n.n24 x2.outa1n.n69 9.0005
R1642 x2.outa1n.n40 x2.outa1n.n4 9.0005
R1643 x2.outa1n.n0 x2.outa1n.n3 9.0005
R1644 x2.outa1n.n26 x2.outa1n.n13 9.0005
R1645 x2.outa1n.n28 x2.outa1n.n21 9.0005
R1646 x2.outa1n.n19 x2.outa1n.n83 9.0005
R1647 x2.outa1n.n88 x2.outa1n.n14 9.0005
R1648 x2.outa1n.n36 x2.outa1n.n15 9.0005
R1649 x2.outa1n.n23 x2.outa1n.n89 9.0005
R1650 x2.outa1n.n41 x2.outa1n.n23 9.0005
R1651 x2.outa1n.n70 x2.outa1n.n22 9.0005
R1652 x2.outa1n.n39 x2.outa1n.n38 9.0005
R1653 x2.outa1n.n43 x2.outa1n.n92 9.0005
R1654 x2.outa1n.n37 x2.outa1n.n91 9.0005
R1655 x2.outa1n.n27 x2.outa1n.n0 9.0005
R1656 x2.outa1n.n43 x2.outa1n 8.03045
R1657 x2.outa1n.n42 x2.outa1n.n52 7.39948
R1658 x2.outa1n.n7 x2.outa1n.n58 7.11558
R1659 x2.outa1n.n8 x2.outa1n.n59 7.11558
R1660 x2.outa1n.n8 x2.outa1n.n77 7.11558
R1661 x2.outa1n.n6 x2.outa1n.n71 7.10699
R1662 x2.outa1n.n9 x2.outa1n.n67 7.10699
R1663 x2.outa1n x2.outa1n.n47 7.10699
R1664 x2.outa1n x2.outa1n.n93 7.10699
R1665 x2.outa1n.n29 x2.outa1n 7.06845
R1666 x2.outa1n.n32 x2.outa1n 7.02503
R1667 x2.outa1n x2.outa1n.n30 6.47885
R1668 x2.outa1n.n30 x2.outa1n 6.47885
R1669 x2.outa1n.n29 x2.outa1n 6.47445
R1670 x2.outa1n.n32 x2.outa1n 6.44145
R1671 x2.outa1n.n33 x2.outa1n 6.43705
R1672 x2.outa1n.n33 x2.outa1n 6.43705
R1673 x2.outa1n.n1 x2.outa1n.n81 5.96108
R1674 x2.outa1n.n30 x2.outa1n 5.70302
R1675 x2.outa1n x2.outa1n.t23 5.66717
R1676 x2.outa1n x2.outa1n.t21 5.66717
R1677 x2.outa1n x2.outa1n.t39 5.66717
R1678 x2.outa1n x2.outa1n.t37 5.66717
R1679 x2.outa1n x2.outa1n.t36 5.66717
R1680 x2.outa1n x2.outa1n.t11 5.66717
R1681 x2.outa1n x2.outa1n.t27 5.66717
R1682 x2.outa1n x2.outa1n.t35 5.66717
R1683 x2.outa1n x2.outa1n.t34 5.66717
R1684 x2.outa1n x2.outa1n.t33 5.66717
R1685 x2.outa1n x2.outa1n.t32 5.66717
R1686 x2.outa1n x2.outa1n.t24 5.66717
R1687 x2.outa1n x2.outa1n.t3 5.66717
R1688 x2.outa1n x2.outa1n.t31 5.66717
R1689 x2.outa1n x2.outa1n.t30 5.66717
R1690 x2.outa1n x2.outa1n.t29 5.66717
R1691 x2.outa1n x2.outa1n.t28 5.66717
R1692 x2.outa1n x2.outa1n.t25 5.66717
R1693 x2.outa1n x2.outa1n.t17 5.66717
R1694 x2.outa1n x2.outa1n.t26 5.66717
R1695 x2.outa1n x2.outa1n.t38 5.66717
R1696 x2.outa1n x2.outa1n.t19 5.66717
R1697 x2.outa1n x2.outa1n.t15 5.66717
R1698 x2.outa1n x2.outa1n.t13 5.66717
R1699 x2.outa1n x2.outa1n.t9 5.66717
R1700 x2.outa1n x2.outa1n.t7 5.66717
R1701 x2.outa1n x2.outa1n.t5 5.66717
R1702 x2.outa1n x2.outa1n.t1 5.66717
R1703 x2.outa1n.n43 x2.outa1n.n48 5.6328
R1704 x2.outa1n x2.outa1n.n33 5.37483
R1705 x2.outa1n.n15 x2.outa1n.n10 5.21802
R1706 x2.outa1n.n2 x2.outa1n.n11 5.21346
R1707 x2.outa1n.n84 x2.outa1n.n2 5.20946
R1708 x2.outa1n.n2 x2.outa1n.n19 5.1879
R1709 x2.outa1n.n21 x2.outa1n.n1 5.1864
R1710 x2.outa1n.n20 x2.outa1n.n1 5.18542
R1711 x2.outa1n.n54 x2.outa1n 5.11553
R1712 x2.outa1n.n57 x2.outa1n 5.11553
R1713 x2.outa1n.n12 x2.outa1n 5.11553
R1714 x2.outa1n.n44 x2.outa1n 5.11553
R1715 x2.outa1n.n76 x2.outa1n 5.11553
R1716 x2.outa1n.n73 x2.outa1n 5.11553
R1717 x2.outa1n.n40 x2.outa1n 5.10066
R1718 x2.outa1n.n66 x2.outa1n 5.10066
R1719 x2.outa1n.n63 x2.outa1n 5.10066
R1720 x2.outa1n.n61 x2.outa1n 5.10066
R1721 x2.outa1n.n45 x2.outa1n 5.10066
R1722 x2.outa1n.n45 x2.outa1n 4.61888
R1723 x2.outa1n.n42 x2.outa1n.n16 4.5005
R1724 x2.outa1n x2.outa1n.n43 4.5005
R1725 x2.outa1n x2.outa1n.n61 4.5005
R1726 x2.outa1n.n9 x2.outa1n.n63 4.5005
R1727 x2.outa1n x2.outa1n.n38 4.5005
R1728 x2.outa1n.n9 x2.outa1n.n66 4.5005
R1729 x2.outa1n.n9 x2.outa1n.n22 4.5005
R1730 x2.outa1n.n6 x2.outa1n.n40 4.5005
R1731 x2.outa1n.n6 x2.outa1n.n73 4.5005
R1732 x2.outa1n.n8 x2.outa1n.n76 4.5005
R1733 x2.outa1n.n6 x2.outa1n.n0 4.5005
R1734 x2.outa1n.n12 x2.outa1n.n8 4.5005
R1735 x2.outa1n.n7 x2.outa1n.n44 4.5005
R1736 x2.outa1n.n42 x2.outa1n.n57 4.5005
R1737 x2.outa1n.n42 x2.outa1n.n54 4.5005
R1738 x2.outa1n x2.outa1n.n45 4.45692
R1739 x2.outa1n.n55 x2.outa1n.t49 3.67052
R1740 x2.outa1n.n52 x2.outa1n.t48 3.67052
R1741 x2.outa1n.n53 x2.outa1n.t22 3.67052
R1742 x2.outa1n.n58 x2.outa1n.t50 3.67052
R1743 x2.outa1n.n56 x2.outa1n.t20 3.67052
R1744 x2.outa1n.n59 x2.outa1n.t51 3.67052
R1745 x2.outa1n.n64 x2.outa1n.t56 3.67052
R1746 x2.outa1n.n48 x2.outa1n.t2 3.67052
R1747 x2.outa1n.n74 x2.outa1n.t53 3.67052
R1748 x2.outa1n.n49 x2.outa1n.t57 3.67052
R1749 x2.outa1n.n51 x2.outa1n.t16 3.67052
R1750 x2.outa1n.n50 x2.outa1n.t18 3.67052
R1751 x2.outa1n.n77 x2.outa1n.t52 3.67052
R1752 x2.outa1n.n75 x2.outa1n.t14 3.67052
R1753 x2.outa1n.n71 x2.outa1n.t54 3.67052
R1754 x2.outa1n.n72 x2.outa1n.t12 3.67052
R1755 x2.outa1n.n67 x2.outa1n.t55 3.67052
R1756 x2.outa1n.n65 x2.outa1n.t8 3.67052
R1757 x2.outa1n.n62 x2.outa1n.t6 3.67052
R1758 x2.outa1n.n47 x2.outa1n.t58 3.67052
R1759 x2.outa1n.n60 x2.outa1n.t4 3.67052
R1760 x2.outa1n.n93 x2.outa1n.t59 3.67052
R1761 x2.outa1n.n46 x2.outa1n.t0 3.67052
R1762 x2.outa1n.n68 x2.outa1n.t10 3.66919
R1763 x2.outa1n.n19 x2.outa1n.n0 2.94695
R1764 x2.outa1n.n22 x2.outa1n.n64 2.94194
R1765 x2.outa1n x2.outa1n.t47 2.83383
R1766 x2.outa1n x2.outa1n.t46 2.83383
R1767 x2.outa1n x2.outa1n.t45 2.83383
R1768 x2.outa1n x2.outa1n.t44 2.83383
R1769 x2.outa1n x2.outa1n.t43 2.83383
R1770 x2.outa1n x2.outa1n.t42 2.83383
R1771 x2.outa1n x2.outa1n.t41 2.83383
R1772 x2.outa1n x2.outa1n.t40 2.83383
R1773 x2.outa1n.n54 x2.outa1n.n53 2.70856
R1774 x2.outa1n.n57 x2.outa1n.n56 2.70856
R1775 x2.outa1n.n76 x2.outa1n.n75 2.70856
R1776 x2.outa1n.n73 x2.outa1n.n72 2.70856
R1777 x2.outa1n.n66 x2.outa1n.n65 2.69998
R1778 x2.outa1n.n63 x2.outa1n.n62 2.69998
R1779 x2.outa1n.n61 x2.outa1n.n60 2.69998
R1780 x2.outa1n.n45 x2.outa1n.n46 2.68153
R1781 x2.outa1n.n40 x2.outa1n.n68 2.67142
R1782 x2.outa1n.n16 x2.outa1n.n55 2.65383
R1783 x2.outa1n.n38 x2.outa1n.n49 2.64525
R1784 x2.outa1n.n0 x2.outa1n.n74 2.63866
R1785 x2.outa1n.n44 x2.outa1n.n50 2.61753
R1786 x2.outa1n.n12 x2.outa1n.n51 2.60539
R1787 x2.outa1n.n9 x2.outa1n 2.54202
R1788 x2.outa1n.n2 x2.outa1n.n10 2.46609
R1789 x2.outa1n.n31 x2.outa1n.n26 2.39588
R1790 x2.outa1n.n82 x2.outa1n.n34 2.38178
R1791 x2.outa1n x2.outa1n.n10 2.14738
R1792 x2.outa1n.n69 x2.outa1n.n27 2.12425
R1793 x2.outa1n.n83 x2.outa1n.n5 2.12425
R1794 x2.outa1n.n85 x2.outa1n.n18 2.12221
R1795 x2.outa1n.n4 x2.outa1n.n3 2.11194
R1796 x2.outa1n.n43 x2.outa1n.n14 1.84964
R1797 x2.outa1n.n25 x2.outa1n.n3 1.81183
R1798 x2.outa1n.n78 x2.outa1n.n25 1.81183
R1799 x2.outa1n.n83 x2.outa1n.n28 1.80966
R1800 x2.outa1n.n82 x2.outa1n.n18 1.80034
R1801 x2.outa1n.n80 x2.outa1n.n28 1.79457
R1802 x2.outa1n.n86 x2.outa1n.n35 1.7935
R1803 x2.outa1n.n36 x2.outa1n.n88 1.7935
R1804 x2.outa1n.n89 x2.outa1n.n5 1.7935
R1805 x2.outa1n.n89 x2.outa1n.n36 1.7935
R1806 x2.outa1n.n35 x2.outa1n.n85 1.7935
R1807 x2.outa1n.n27 x2.outa1n.n26 1.79209
R1808 x2.outa1n.n91 x2.outa1n.n41 1.79133
R1809 x2.outa1n.n4 x2.outa1n.n70 1.78724
R1810 x2.outa1n.n92 x2.outa1n.n39 1.78724
R1811 x2.outa1n.n70 x2.outa1n.n39 1.78201
R1812 x2.outa1n.n69 x2.outa1n.n41 1.76712
R1813 x2.outa1n.n6 x2.outa1n.n9 1.5845
R1814 x2.outa1n.n8 x2.outa1n.n6 1.5845
R1815 x2.outa1n.n8 x2.outa1n.n7 1.5845
R1816 x2.outa1n.n2 x2.outa1n.n1 1.56706
R1817 x2.outa1n.n68 x2.outa1n 1.5402
R1818 x2.outa1n.n55 x2.outa1n 1.53803
R1819 x2.outa1n.n52 x2.outa1n 1.53803
R1820 x2.outa1n.n53 x2.outa1n 1.53803
R1821 x2.outa1n.n58 x2.outa1n 1.53803
R1822 x2.outa1n.n56 x2.outa1n 1.53803
R1823 x2.outa1n.n59 x2.outa1n 1.53803
R1824 x2.outa1n.n64 x2.outa1n 1.53803
R1825 x2.outa1n.n48 x2.outa1n 1.53803
R1826 x2.outa1n.n74 x2.outa1n 1.53803
R1827 x2.outa1n.n49 x2.outa1n 1.53803
R1828 x2.outa1n.n51 x2.outa1n 1.53803
R1829 x2.outa1n.n50 x2.outa1n 1.53803
R1830 x2.outa1n.n77 x2.outa1n 1.53803
R1831 x2.outa1n.n75 x2.outa1n 1.53803
R1832 x2.outa1n.n71 x2.outa1n 1.53803
R1833 x2.outa1n.n72 x2.outa1n 1.53803
R1834 x2.outa1n.n67 x2.outa1n 1.53803
R1835 x2.outa1n.n65 x2.outa1n 1.53803
R1836 x2.outa1n.n62 x2.outa1n 1.53803
R1837 x2.outa1n.n47 x2.outa1n 1.53803
R1838 x2.outa1n.n60 x2.outa1n 1.53803
R1839 x2.outa1n.n93 x2.outa1n 1.53803
R1840 x2.outa1n.n46 x2.outa1n 1.53803
R1841 x2.outa1n.n13 x2.outa1n.n12 1.49928
R1842 x2.outa1n.n37 x2.outa1n.n15 1.33883
R1843 x2.outa1n.n81 x2.outa1n.n17 1.33258
R1844 x2.outa1n.n79 x2.outa1n.n20 1.32503
R1845 x2.outa1n.n21 x2.outa1n.n13 1.32146
R1846 x2.outa1n.n23 x2.outa1n.n11 1.31924
R1847 x2.outa1n.n84 x2.outa1n.n24 1.30327
R1848 x2.outa1n.n7 x2.outa1n.n42 1.3006
R1849 x2.outa1n.n38 x2.outa1n.n37 1.23954
R1850 x2.outa1n.n91 x2.outa1n.n90 1.23142
R1851 x2.outa1n.n17 x2.outa1n.n16 1.22991
R1852 x2.outa1n.n87 x2.outa1n.n86 1.227
R1853 x2.outa1n.n40 x2.outa1n.n24 1.21218
R1854 x2.outa1n.n30 x2.outa1n.n29 1.19479
R1855 x2.outa1n.n33 x2.outa1n.n32 1.17383
R1856 x2.outa1n.n79 x2.outa1n.n44 1.15164
R1857 x2.outa1n.n23 x2.outa1n.n22 1.10485
C0 x1.xtr.top a_n2798_n19539# 0.314f
C1 x1.level_shift_0[3].XM2.D0 x1.level_shift_0[3].in_n 0.13434f
C2 x1.level_shift_0[3].XM7.D0 trim[6] 0.03336f
C3 x1.XQ2_7.E x1.xtr.XM0[13].S 0.30307f
C4 a_2435_n22299# a_2648_n22299# 0.74283f
C5 x2.outa1p x2.XMB4.S0 0.04223f
C6 x1.level_shift_0[5].out x1.level_shift_0[6].XM7.G0 0.11599f
C7 x1.xamp.XM8.D0 x1.xamp.out1p 0.13917f
C8 x1.xres.XR1[15].R2 a_2009_n22299# 0.06253f
C9 x1.x1[0].XM2.D0 x1.x1[0].in_p 1.37309f
C10 x1.x1[5].XM2.D0 x1.x1[4].XM7.D0 0.04515f
C11 x1.level_shift_0[1].out x1.x1[2].out 2.22391f
C12 x1.level_shift_0[0].out x1.level_shift_0[3].XM2.D0 0.01128f
C13 x1.x1[4].out x1.xtr.XM0[10].S 0.13825f
C14 x1.x1[7].XM2.D0 x1.level_shift_0[6].in_n 0.01864f
C15 x1.x1[3].in_n vdd 0.05434f
C16 a_944_n22299# x1.xres.XR1[11].R2 0.05732f
C17 x1.level_shift_0[6].XM2.D0 x1.x1[6].out 0.0557f
C18 x1.level_shift_0[4].XM7.G0 x1.level_shift_0[3].out 0.03604f
C19 x1.level_shift_0[5].in_n vdd 0.37584f
C20 x1.xamp.XM8.D0 x1.xamp.out1n 0.24835f
C21 x1.level_shift_0[2].XM7.D0 x1.level_shift_0[3].XM2.D0 0.04779f
C22 x1.x1[5].XM7.G0 x1.x1[5].out 0.02955f
C23 x1.xamp.vbn1 vdd 0.04553f
C24 x1.level_shift_0[6].in_n trim[4] 0.06148f
C25 x1.x1[5].out x1.x1[6].out 0.06131f
C26 x1.x1[2].XM7.G0 x1.x1[2].XM7.D0 2.21217f
C27 x1.xres.d x1.ena_b_h 0.05945f
C28 x1.xtr.top a_944_n22299# 0.01334f
C29 x1.x1[6].in_n x1.x1[6].XM2.D0 0.20725f
C30 x1.level_shift_0[1].XM7.G0 x1.level_shift_0[1].XM2.D0 2.18793f
C31 x1.x1[8].XM2.D0 x1.level_shift_0[7].in_n 0.01864f
C32 a_n2798_n19539# x1.XQ2_7.E 0.04457f
C33 x1.xres.XR1[18].R1 a_2648_n22299# 0.0564f
C34 a_2222_n22299# x1.xres.c 0.01045f
C35 x1.XM1.G0 a_305_n22299# 0.02162f
C36 x1.x1[1].out x1.level_shift_0[0].XM2.D0 0.01015f
C37 x1.level_shift_0[3].out x1.xtr.XM0[9].S 0.13819f
C38 x1.vbg x1.vs1 0.1727f
C39 x1.xamp.out1p vdd 6.9611f
C40 vdd ibias1_250n 0.42955f
C41 x1.vs2 a_n1186_n22299# 0.01543f
C42 x1.x1[3].out x1.level_shift_0[1].out 1.28902f
C43 x1.level_shift_0[7].XM2.D0 x1.level_shift_0[6].out 0.09195f
C44 x1.x1[0].XM7.D0 vdd 2.6882f
C45 x1.x1[5].XM7.G0 trim[5] 0.01658f
C46 x1.x1[5].XM2.D0 x1.x1[4].out 0.03269f
C47 x1.level_shift_0[4].XM7.D0 x1.level_shift_0[4].XM2.D0 0.05094f
C48 x1.xamp.out1n vdd 6.54955f
C49 x1.level_shift_0[5].out x1.x1[7].out 0.17818f
C50 a_3074_n22299# x1.ena_b_h 0.0455f
C51 x1.x1[1].XM2.D0 x1.x1[1].XM7.D0 0.04746f
C52 x1.xamp.vbn2 vdd 3.43915f
C53 x1.level_shift_0[1].in_n x1.x1[2].XM7.G0 0.20064f
C54 vdd vbg 37.3744f
C55 x1.x1[2].XM7.G0 x1.x1[2].in_n 1.46694f
C56 x1.x1[5].XM7.D0 x1.x1[6].in_n 0.03829f
C57 a_n334_n22299# a_n121_n22299# 0.74283f
C58 x1.x1[4].XM2.D0 x1.x1[3].XM7.D0 0.04515f
C59 x1.xres.XR1[2].R1 a_n547_n22299# 0.05172f
C60 x2.outb1n vdd 1.69641f
C61 x1.x1[4].out trim[6] 0.02709f
C62 x2.outa1p x2.vbn1 0.02245f
C63 x1.level_shift_0[3].in_n vdd 0.37596f
C64 x1.level_shift_0[3].out trim[8] 0.06887f
C65 x1.level_shift_0[5].out x1.level_shift_0[5].XM7.D0 2.65754f
C66 a_n2798_n18803# x1.XQ2_7.E 0.02569f
C67 x1.XQ2_7.E a_n2798_n16963# 0.02136f
C68 x1.x1[8].in_n x1.x1[8].XM2.D0 0.20663f
C69 x1.level_shift_0[0].out vdd 0.56202f
C70 x1.level_shift_0[2].XM2.D0 vdd 1.28827f
C71 x1.ena_b_h vdd 15.1625f
C72 x1.vs2 a_2648_n22299# 0.07258f
C73 x1.level_shift_0[2].XM7.D0 vdd 2.70175f
C74 x1.x1[8].XM7.G0 trim[0] 0.17931f
C75 x1.XM1.G0 x1.xamp.XM8.S1 4.54066f
C76 x1.x1[3].XM7.G0 x1.x1[3].XM7.D0 2.21217f
C77 x1.level_shift_0[5].out x1.xtr.XM0[5].S 0.13737f
C78 x2.outb1p x2.outa1p 0.23959f
C79 a_n2798_n16227# a_n2798_n16595# 0.1176f
C80 x1.x1[3].XM7.G0 x1.x1[2].out 0.01703f
C81 x1.x1[5].XM7.G0 x1.x1[5].in_n 1.46694f
C82 x1.xres.XR1[16].R2 x1.xres.c 0.08453f
C83 x2.outa1n x2.vbn2 0.17537f
C84 x1.level_shift_0[7].XM7.D0 x1.level_shift_0[7].XM2.D0 0.05094f
C85 x1.level_shift_0[2].out trim[6] 0.01767f
C86 x1.level_shift_0[3].XM7.D0 x1.level_shift_0[3].out 2.67516f
C87 x1.x1[4].XM7.G0 vdd 2.56202f
C88 x1.level_shift_0[5].in_n x1.level_shift_0[5].XM7.D0 0.10509f
C89 x1.level_shift_0[7].out x1.xtr.XM0[1].S 0.13704f
C90 x1.vs2 a_n121_n22299# 0.01407f
C91 x1.x1[4].XM2.D0 x1.x1[3].out 0.03246f
C92 x1.x1[7].XM7.D0 trim[1] 0.07712f
C93 x1.x1[8].out x1.xtr.XM0[2].S 0.1372f
C94 x1.x1[1].XM7.G0 x1.level_shift_0[0].in_n 0.20038f
C95 x1.x1[8].XM7.G0 x1.x1[8].XM7.D0 2.21217f
C96 a_n2798_n13283# x1.XQ2_7.E 0.06565f
C97 x1.ena_b_h x2.XMB4.S0 0.47788f
C98 x1.x1[5].out x1.level_shift_0[4].XM2.D0 0.01086f
C99 x1.level_shift_0[5].XM2.D0 x1.x1[4].out 0.04101f
C100 x1.XM1.G0 a_2861_n22299# 0.02162f
C101 x1.x1[3].XM7.D0 trim[9] 0.08247f
C102 x1.x1[0].XM7.G0 x1.x1[0].XM2.D0 2.1839f
C103 x1.x1[5].out x1.XQ2_7.E 0.40742f
C104 x1.vs1 x1.XQ2_7.E 0.04034f
C105 a_n2798_n14019# a_n2798_n14387# 0.1176f
C106 x1.level_shift_0[0].out x1.level_shift_0[0].XM7.D0 2.72048f
C107 x1.x1[2].XM2.D0 x1.x1[1].XM7.D0 0.04515f
C108 x1.level_shift_0[1].XM7.D0 x1.x1[2].out 0.23562f
C109 x1.vs2 x1.level_shift_0[0].XM2.D0 0.37479f
C110 x2.outa1p x2.vbp1 0.5881f
C111 x1.level_shift_0[5].in_n x1.x1[6].XM7.D0 0.08111f
C112 x1.xres.XR1[4].R2 a_n121_n22299# 0.02466f
C113 x1.xres.XR1[5].R1 x1.xres.XR1[6].R1 0.24692f
C114 x1.level_shift_0[2].in_n trim[10] 2.8642f
C115 x1.xres.c x1.xamp.out1p 3.61976f
C116 x1.x1[3].XM7.G0 x1.x1[3].out 0.02992f
C117 x1.level_shift_0[4].XM2.D0 x1.x1[2].out 0.0236f
C118 x1.level_shift_0[2].XM7.G0 x1.x1[2].out 0.03591f
C119 x1.x1[6].in_n trim[5] 0.54236f
C120 x1.XQ2_7.E x1.x1[2].out 0.40892f
C121 x1.level_shift_0[7].XM2.D0 trim[0] 1.35191f
C122 x1.xres.c x1.xamp.out1n 1.90173f
C123 x1.level_shift_0[5].out x1.x1[6].out 0.59705f
C124 a_n2798_n13283# a_n2798_n13651# 0.1176f
C125 x1.level_shift_0[5].XM2.D0 x1.level_shift_0[2].out 0.0426f
C126 x1.vbg x2.outa1p 2.07937f
C127 x1.XQ2_7.E x1.xtr.XM0[7].S 0.30301f
C128 x1.level_shift_0[4].XM7.G0 x1.level_shift_0[3].XM7.D0 0.01219f
C129 x2.vbn1 vbg 1.33569f
C130 x1.x1[8].XM7.G0 x1.x1[8].out 0.02904f
C131 trim[7] trim[8] 0.04308f
C132 x1.level_shift_0[6].XM2.D0 x1.level_shift_0[6].in_n 0.13434f
C133 x2.outb1n x2.vbn1 10.9605f
C134 x1.xtr.top a_2222_n22299# 0.01527f
C135 x1.level_shift_0[0].XM7.G0 vdd 2.73267f
C136 x1.XQ2_7.E x1.xtr.XM0[1].S 0.38163f
C137 x1.x1[4].out x1.level_shift_0[3].out 1.51626f
C138 a_n2798_n19171# a_n2798_n19539# 0.1176f
C139 x1.level_shift_0[1].XM7.D0 x1.level_shift_0[1].XM2.D0 0.05094f
C140 x1.XM1.G0 a_1583_n22299# 0.02137f
C141 x1.level_shift_0[4].out trim[6] 0.06886f
C142 x1.level_shift_0[5].in_n x1.x1[6].out 0.02503f
C143 x1.xtr.XM0[7].S a_n2798_n15859# 0.1873f
C144 x1.xres.d a_3074_n22299# 0.02948f
C145 a_n2798_n19539# x1.vs2 0.01509f
C146 vdd trim[2] 0.46633f
C147 x1.level_shift_0[4].XM2.D0 x1.x1[3].out 0.01103f
C148 x1.level_shift_0[2].XM7.G0 x1.x1[3].out 0.03178f
C149 x1.xres.c x1.ena_b_h 0.11283f
C150 x1.XM1.G0 x1.xamp.XM6.S0 31.1146f
C151 x1.x1[3].out x1.XQ2_7.E 0.40821f
C152 x1.level_shift_0[0].out x1.level_shift_0[1].XM7.G0 0.0761f
C153 x2.outb1p vbg 1.0409f
C154 x1.xtr.XM0[4].S a_n2798_n14755# 0.1873f
C155 x1.level_shift_0[7].XM2.D0 x1.level_shift_0[6].XM7.D0 0.04779f
C156 x1.level_shift_0[3].XM2.D0 vdd 1.28659f
C157 x2.outa1p ibias2_1u 0.01168f
C158 x2.outb1p x2.outb1n 40.6479f
C159 x1.x1[1].in_n x1.x1[1].XM2.D0 0.2065f
C160 x1.x1[1].out x1.x1[2].out 0.06132f
C161 x1.x1[2].out trim[12] 0.17012f
C162 x1.xtr.top x1.xres.XR1[17].R1 0.06938f
C163 x1.level_shift_0[6].XM7.G0 trim[2] 0.09307f
C164 x1.level_shift_0[7].XM7.G0 vdd 2.56032f
C165 x1.xtr.XM0[1].S a_n2798_n13651# 0.19545f
C166 x1.x1[5].XM2.D0 x1.level_shift_0[4].in_n 0.01864f
C167 x1.x1[8].out x1.level_shift_0[7].XM2.D0 0.02572f
C168 x1.xres.d vdd 7.13174f
C169 x1.vs2 a_944_n22299# 0.01238f
C170 x1.xtr.XM0[11].S x1.xtr.XM0[12].S 0.14646f
C171 x1.x1[8].XM7.D0 x1.x1[8].XM2.D0 0.04746f
C172 x1.level_shift_0[2].XM2.D0 x1.level_shift_0[1].out 0.06946f
C173 x1.x1[7].XM7.D0 trim[2] 0.27368f
C174 x1.XM1.G0 x1.xres.XR1[14].R1 0.05085f
C175 x1.level_shift_0[0].XM7.D0 x1.level_shift_0[0].XM7.G0 2.21752f
C176 x1.ena_b_h x2.outb1p 0.01692f
C177 x1.x1[4].XM7.D0 trim[7] 0.07712f
C178 x1.level_shift_0[2].XM7.D0 x1.level_shift_0[1].out 0.04336f
C179 x1.xres.XR1[15].R2 x1.xres.XR1[12].R2 0.02835f
C180 a_n2798_n18803# a_n2798_n19171# 0.1176f
C181 x2.vbp1 vbg 0.42407f
C182 x1.level_shift_0[3].XM7.D0 trim[8] 0.21012f
C183 x1.vbg x1.xamp.out1p 0.04091f
C184 x1.level_shift_0[5].XM2.D0 x1.level_shift_0[4].out 0.05275f
C185 x1.level_shift_0[4].in_n trim[6] 2.99024f
C186 x1.level_shift_0[4].XM7.G0 x1.x1[4].out 0.02095f
C187 x1.XM1.G0 a_n1186_n22299# 0.05818f
C188 x1.x1[0].XM7.D0 ena 0.0768f
C189 x1.xamp.XM8.D0 vdd 15.9016f
C190 x1.x1[3].XM7.G0 x1.x1[3].in_n 1.46694f
C191 a_731_n22299# a_944_n22299# 0.74283f
C192 x1.XQ2_7.E a_n2798_n18435# 0.02369f
C193 x1.xres.XR1[7].R2 a_305_n22299# 0.06253f
C194 x1.vbg x1.xamp.out1n 0.03078f
C195 x1.vbg x1.xres.XR1[3].R2 0.02835f
C196 x1.x1[1].out x1.level_shift_0[1].XM2.D0 0.01278f
C197 x1.x1[2].XM7.D0 x1.x1[2].out 2.71526f
C198 x1.x1[1].out x1.x1[2].XM2.D0 0.03217f
C199 x1.level_shift_0[5].out x1.XQ2_7.E 0.40675f
C200 x1.vbg vbg 8.49202f
C201 x1.XQ2_7.E x1.xtr.XM0[12].S 0.30301f
C202 x1.level_shift_0[1].XM2.D0 trim[12] 1.35191f
C203 x1.ena_b_h x2.vbp1 1.50138f
C204 x1.x1[4].XM7.D0 trim[8] 0.27036f
C205 x1.level_shift_0[3].XM7.G0 x1.x1[2].out 0.02642f
C206 x1.vbg x2.outb1n 0.69567f
C207 x2.XM9.D0_0 x2.XMOP.G0_0 58.8406f
C208 x1.xtr.top a_n547_n22299# 0.01959f
C209 x1.x1[7].out trim[2] 0.14779f
C210 x1.xtr.XM0[5].S x1.xtr.XM0[6].S 0.14646f
C211 x1.level_shift_0[4].XM7.G0 x1.level_shift_0[2].out 0.01728f
C212 a_2222_n22299# a_2435_n22299# 0.74283f
C213 x1.XM1.G0 x1.xres.XR1[1].R1 0.16396f
C214 x1.xres.XR1[14].R1 a_2009_n22299# 0.05172f
C215 x1.level_shift_0[5].in_n x1.x1[6].in_n 0.44473f
C216 x1.xres.XR1[10].R1 a_944_n22299# 0.0564f
C217 x1.XM1.S0 x1.ena_b_h 0.02342f
C218 x1.vs1 x1.vs2 0.2857f
C219 x1.x1[4].XM2.D0 x1.level_shift_0[3].in_n 0.01864f
C220 x1.vbg x1.ena_b_h 5.83597f
C221 x1.xtr.XM0[13].S x1.xtr.XM0[14].S 0.14632f
C222 x1.x1[4].XM7.D0 x1.level_shift_0[3].XM7.D0 0.01364f
C223 x1.ena_b_h ena 0.1509f
C224 x1.level_shift_0[5].XM7.D0 trim[2] 0.03336f
C225 x1.XM1.G0 a_2648_n22299# 0.02138f
C226 trim[3] trim[2] 0.02303f
C227 x1.level_shift_0[7].XM7.G0 x1.x1[7].out 0.01082f
C228 ibias2_1u vbg 0.2474f
C229 x1.level_shift_0[5].XM2.D0 trim[4] 1.35191f
C230 x1.level_shift_0[6].XM7.D0 x1.level_shift_0[6].XM2.D0 0.05094f
C231 a_n973_n22299# vdd 0.01193f
C232 x1.level_shift_0[1].in_n x1.x1[2].out 0.04379f
C233 x1.xtr.top a_518_n22299# 0.01527f
C234 x1.xtr.XM0[10].S a_n2798_n16963# 0.1873f
C235 a_n547_n22299# x1.XQ2_7.E 0.01421f
C236 x1.x1[2].XM7.D0 x1.x1[2].XM2.D0 0.04746f
C237 x1.level_shift_0[3].XM7.G0 x1.x1[3].out 0.02147f
C238 x1.level_shift_0[6].XM7.G0 vdd 2.56144f
C239 x1.x1[4].out trim[8] 0.16098f
C240 x1.x1[1].XM7.D0 x1.ena_b_h 0.01218f
C241 x1.XM1.G0 a_n121_n22299# 0.02991f
C242 x1.level_shift_0[5].XM7.G0 x1.level_shift_0[5].XM2.D0 2.18793f
C243 x1.x1[4].XM7.G0 x1.x1[4].XM2.D0 2.1839f
C244 x2.XMB4.S0 vdd 4.93317f
C245 x1.xres.c x1.xres.d 10.8177f
C246 x1.level_shift_0[5].out x1.level_shift_0[6].in_n 0.17869f
C247 x1.x1[7].XM7.D0 vdd 2.70469f
C248 x1.x1[6].out x1.xtr.XM0[6].S 0.13765f
C249 x1.ena_b_h ibias2_1u 2.03053f
C250 x1.level_shift_0[0].XM7.D0 vdd 2.75495f
C251 x1.level_shift_0[3].XM2.D0 x1.level_shift_0[1].out 0.01035f
C252 x1.xtr.top x1.xres.XR1[9].R1 0.06222f
C253 x1.x1[4].out x1.level_shift_0[3].XM7.D0 0.18795f
C254 x1.level_shift_0[4].XM7.D0 trim[6] 0.21012f
C255 x1.level_shift_0[2].out trim[8] 0.05821f
C256 x1.x1[5].XM7.D0 x1.x1[5].XM2.D0 0.04746f
C257 x1.XQ2_7.E a_n2798_n16595# 0.02136f
C258 x1.xres.XR1[16].R2 a_2435_n22299# 0.02466f
C259 x1.xres.XR1[17].R1 x1.xres.XR1[18].R1 0.24693f
C260 x1.XM1.G0 x1.xres.XR1[6].R1 0.05131f
C261 x1.xres.XR1[2].R1 a_n973_n22299# 0.05152f
C262 x1.level_shift_0[4].in_n x1.level_shift_0[3].out 0.05038f
C263 x1.level_shift_0[1].in_n x1.level_shift_0[1].XM2.D0 0.13434f
C264 x1.level_shift_0[1].in_n x1.x1[2].XM2.D0 0.01864f
C265 x1.level_shift_0[0].out x1.level_shift_0[1].XM7.D0 0.03689f
C266 x1.xres.XR1[8].R2 x1.xres.XR1[11].R2 0.02835f
C267 x1.x1[7].XM7.G0 x1.x1[7].XM2.D0 2.1839f
C268 x1.level_shift_0[4].out x1.level_shift_0[4].XM7.G0 0.01032f
C269 x1.level_shift_0[0].XM2.D0 x1.level_shift_0[0].in_n 0.13434f
C270 x1.x1[2].in_n x1.x1[2].XM2.D0 0.20728f
C271 x1.level_shift_0[2].XM2.D0 x1.level_shift_0[1].XM7.D0 0.04779f
C272 x1.level_shift_0[3].out trim[4] 0.05749f
C273 x1.level_shift_0[0].out trim[14] 0.06887f
C274 x1.XQ2_7.E a_n2798_n14387# 0.02852f
C275 x1.level_shift_0[2].XM7.D0 x1.level_shift_0[1].XM7.D0 0.0167f
C276 x1.ena_b_h trim[14] 0.08508f
C277 x1.x1[4].XM7.D0 x1.x1[4].out 2.71182f
C278 x1.x1[6].out trim[2] 0.12689f
C279 x1.x1[7].in_n trim[2] 0.11995f
C280 x1.x1[5].XM7.D0 trim[6] 0.27036f
C281 x1.level_shift_0[0].out x1.level_shift_0[4].XM2.D0 0.01448f
C282 x1.x1[7].out vdd 0.92904f
C283 x1.level_shift_0[0].out x1.level_shift_0[2].XM7.G0 0.04472f
C284 x1.level_shift_0[2].in_n x1.x1[3].XM7.D0 0.08111f
C285 x1.level_shift_0[2].XM7.G0 x1.level_shift_0[2].XM2.D0 2.18793f
C286 x1.level_shift_0[0].out x1.XQ2_7.E 0.40944f
C287 x1.vs2 a_2222_n22299# 0.044f
C288 x1.level_shift_0[5].XM7.G0 x1.level_shift_0[3].out 0.06134f
C289 x1.ena_b_h x1.XQ2_7.E 2.39618f
C290 trim[11] trim[12] 0.04615f
C291 x1.level_shift_0[2].in_n x1.x1[2].out 0.02118f
C292 x1.level_shift_0[3].XM7.D0 x1.level_shift_0[2].out 0.05146f
C293 a_n2798_n18803# x1.xtr.XM0[14].S 0.19209f
C294 x1.xtr.XM0[12].S a_n2798_n17699# 0.1873f
C295 x1.level_shift_0[2].XM7.D0 x1.level_shift_0[2].XM7.G0 2.21752f
C296 a_1796_n22299# x1.xres.c 0.01045f
C297 x1.x1[8].out x1.xtr.XM0[1].S 0.01598f
C298 x1.x1[8].in_n trim[1] 0.5026f
C299 x1.ena_b_h x1.x1[0].in_p 0.01245f
C300 x1.xres.c vdd 8.12576f
C301 x1.level_shift_0[5].XM7.D0 vdd 2.70116f
C302 x1.xtr.XM0[8].S x1.xtr.XM0[9].S 0.14646f
C303 x1.x1[7].out x1.level_shift_0[6].XM7.G0 0.09219f
C304 x1.level_shift_0[5].XM2.D0 x1.level_shift_0[4].XM7.D0 0.04779f
C305 x1.x1[2].XM7.D0 x1.x1[3].in_n 0.03829f
C306 x1.level_shift_0[1].XM7.G0 vdd 2.64437f
C307 x1.x1[7].XM7.D0 x1.x1[7].out 2.70625f
C308 x2.outa1p x2.outa1n 47.5679f
C309 x1.x1[1].in_n x1.x1[0].XM7.D0 0.03829f
C310 x1.x1[4].in_n trim[8] 0.13067f
C311 x1.level_shift_0[4].XM7.G0 x1.level_shift_0[4].in_n 1.56081f
C312 x1.vbg x1.xres.d 0.14867f
C313 x1.level_shift_0[6].XM7.G0 x1.level_shift_0[5].XM7.D0 0.01219f
C314 x1.XQ2_7.E a_n2798_n18067# 0.02136f
C315 x1.x1[5].out trim[6] 0.15359f
C316 x1.x1[6].XM7.D0 vdd 2.70469f
C317 x1.x1[1].out x1.level_shift_0[3].in_n 0.01123f
C318 x1.XM1.G0 a_944_n22299# 0.02138f
C319 a_n547_n22299# a_n334_n22299# 0.74283f
C320 x1.xtr.XM0[2].S x1.xtr.XM0[3].S 0.14646f
C321 x1.level_shift_0[2].in_n x1.x1[3].out 0.0387f
C322 x1.level_shift_0[1].out vdd 0.56109f
C323 x1.x1[2].XM7.D0 trim[11] 0.07743f
C324 x2.outb1p vdd 1.63107f
C325 x1.XM1.G0 x1.xamp.vbp2 9.71603f
C326 x1.level_shift_0[6].in_n trim[1] 0.01542f
C327 x1.level_shift_0[0].out x1.x1[1].out 2.12411f
C328 x1.level_shift_0[7].out x1.level_shift_0[7].XM7.G0 0.03383f
C329 x1.x1[1].out x1.ena_b_h 0.04588f
C330 x1.XQ2_7.E x1.xtr.XM0[6].S 0.30301f
C331 x1.level_shift_0[0].out trim[12] 0.05697f
C332 a_2435_n22299# x1.ena_b_h 0.0242f
C333 x1.ena_b_h trim[12] 0.02195f
C334 x1.xamp.XM6.S0 x1.xamp.XM8.S1 8.06793f
C335 x1.level_shift_0[7].in_n trim[2] 0.06148f
C336 x1.x1[2].out trim[6] 0.0276f
C337 x1.vs2 x1.xres.XR1[16].R2 0.02925f
C338 x1.level_shift_0[5].out x1.level_shift_0[6].XM7.D0 0.03182f
C339 x1.xtr.XM0[14].S x1.x1[2].out 0.14023f
C340 x1.level_shift_0[1].XM7.G0 x1.level_shift_0[0].XM7.D0 0.01219f
C341 x1.x1[4].out x1.level_shift_0[2].out 0.9964f
C342 x1.level_shift_0[0].XM7.G0 trim[14] 0.09307f
C343 trim[5] trim[6] 0.09325f
C344 x1.xtr.XM0[6].S a_n2798_n15859# 0.19209f
C345 x1.level_shift_0[4].XM7.D0 x1.level_shift_0[3].out 0.05643f
C346 x1.xres.XR1[3].R2 a_n334_n22299# 0.05732f
C347 x1.x1[5].XM7.G0 vdd 2.56202f
C348 x2.vbp1 vdd 15.116f
C349 a_n2798_n16963# a_n2798_n17331# 0.1176f
C350 x1.x1[4].XM7.D0 x1.x1[4].in_n 0.01441f
C351 x1.level_shift_0[7].XM7.G0 x1.level_shift_0[7].in_n 1.56081f
C352 x1.x1[6].XM7.G0 trim[4] 0.17079f
C353 x1.vs2 a_n547_n22299# 0.01294f
C354 x1.x1[0].XM7.G0 x1.x1[0].XM7.D0 2.22295f
C355 x1.x1[7].in_n vdd 0.05434f
C356 x1.x1[6].out vdd 0.93003f
C357 x1.xtr.XM0[3].S a_n2798_n14755# 0.19209f
C358 x1.level_shift_0[5].XM2.D0 x1.x1[5].out 0.01824f
C359 a_1583_n22299# x1.xres.XR1[12].R2 0.02466f
C360 x1.level_shift_0[3].XM7.G0 x1.level_shift_0[3].in_n 1.56081f
C361 x1.level_shift_0[4].in_n trim[8] 0.06148f
C362 x2.diffa x2.diffb 0.02609f
C363 x1.XM1.S0 vdd 2.52411f
C364 x1.vbg vdd 11.4357f
C365 x1.vs1 x1.XM1.G0 0.1449f
C366 x1.x1[3].XM7.D0 x1.x1[3].XM2.D0 0.04746f
C367 x1.x1[3].out trim[6] 0.0147f
C368 x1.level_shift_0[0].out x1.level_shift_0[3].XM7.G0 0.04838f
C369 vdd ena 0.01111f
C370 x2.XMB4.S0 x2.vbp1 0.52598f
C371 x1.x1[3].XM2.D0 x1.x1[2].out 0.0323f
C372 x1.level_shift_0[6].XM7.G0 x1.x1[6].out 0.03695f
C373 x1.x1[5].in_n x1.x1[5].XM2.D0 0.20723f
C374 x1.x1[1].XM7.D0 trim[13] 0.08413f
C375 x1.level_shift_0[2].XM7.D0 x1.level_shift_0[3].XM7.G0 0.01219f
C376 x1.x1[4].XM2.D0 vdd 1.28662f
C377 x1.vbg a_n973_n22299# 0.02444f
C378 x1.vs2 a_518_n22299# 0.01238f
C379 x1.x1[7].XM7.D0 x1.x1[7].in_n 0.01441f
C380 x2.outa1n vbg 3.08147f
C381 x1.vs2 x1.xres.XR1[3].R2 0.01819f
C382 x1.xtr.top a_3074_n22299# 0.04423f
C383 x1.level_shift_0[6].out trim[2] 0.06886f
C384 trim[1] trim[0] 0.02297f
C385 x1.x1[1].XM2.D0 x1.level_shift_0[0].in_n 0.01864f
C386 x1.level_shift_0[7].out vdd 0.53528f
C387 x1.xres.d x1.XQ2_7.E 0.03007f
C388 x2.outb1n x2.outa1n 0.17627f
C389 x1.x1[1].XM7.D0 vdd 2.71798f
C390 x1.level_shift_0[4].in_n x1.level_shift_0[3].XM7.D0 0.05008f
C391 x2.XM9.D0_0 x2.vbn2 13.8108f
C392 x1.x1[0].XM7.G0 x1.ena_b_h 0.17327f
C393 x1.level_shift_0[4].XM7.D0 x1.level_shift_0[4].XM7.G0 2.21752f
C394 x1.x1[5].in_n trim[6] 0.11969f
C395 a_n2798_n14755# a_n2798_n15123# 0.1176f
C396 x1.level_shift_0[2].in_n x1.x1[3].in_n 0.44763f
C397 x1.x1[1].out x1.level_shift_0[0].XM7.G0 0.09084f
C398 vdd ibias2_1u 4.94147f
C399 x1.level_shift_0[0].out x1.level_shift_0[1].in_n 0.05237f
C400 x1.x1[6].XM7.D0 x1.level_shift_0[5].XM7.D0 0.01364f
C401 a_518_n22299# a_731_n22299# 0.74283f
C402 x1.x1[6].XM7.D0 trim[3] 0.07712f
C403 x2.XMOP.G0_0 x2.vbn2 8.55077f
C404 x1.xres.XR1[6].R1 a_305_n22299# 0.05172f
C405 x1.x1[3].XM7.G0 vdd 2.56202f
C406 x1.xres.XR1[3].R2 x1.xres.XR1[4].R2 0.19948f
C407 x1.ena_b_h x2.outa1n 0.12207f
C408 x1.xtr.top a_1796_n22299# 0.01334f
C409 x2.outb1p x2.vbn1 4.83851f
C410 x1.level_shift_0[7].XM7.G0 x1.level_shift_0[6].out 0.02258f
C411 x1.x1[5].out x1.level_shift_0[3].out 0.67658f
C412 x1.vs2 x1.ena_b_h 5.29026f
C413 a_n2798_n17699# a_n2798_n18067# 0.1176f
C414 x1.level_shift_0[1].XM7.G0 x1.level_shift_0[1].out 0.01073f
C415 x1.level_shift_0[6].in_n trim[2] 2.98007f
C416 x1.level_shift_0[7].in_n vdd 0.37572f
C417 x1.xtr.XM0[14].S a_n2798_n18435# 0.1873f
C418 x1.xtr.top a_n973_n22299# 0.02869f
C419 trim[13] trim[14] 0.09517f
C420 x1.x1[6].XM7.G0 x1.x1[6].XM2.D0 2.1839f
C421 x1.x1[7].out x1.x1[6].out 0.0613f
C422 x2.XMB4.S0 ibias2_1u 0.01973f
C423 x1.xres.XR1[14].R1 a_1583_n22299# 0.05152f
C424 x1.x1[1].XM7.D0 x1.level_shift_0[0].XM7.D0 0.01364f
C425 x1.level_shift_0[1].XM7.D0 vdd 2.70312f
C426 vdd trim[14] 0.67348f
C427 x1.x1[6].in_n vdd 0.05434f
C428 x1.xamp.XM8.S1 x1.xamp.XM1.S0 0.01127f
C429 a_2648_n22299# a_2861_n22299# 0.74283f
C430 x1.level_shift_0[4].XM2.D0 vdd 1.28659f
C431 x1.level_shift_0[2].XM7.G0 vdd 2.59673f
C432 x1.XQ2_7.E vdd 0.67326f
C433 x1.vs2 x1.xres.XR1[8].R2 0.02962f
C434 x1.x1[6].out x1.level_shift_0[5].XM7.D0 0.15904f
C435 x1.xtr.XM0[9].S a_n2798_n16963# 0.19209f
C436 x1.x1[7].in_n trim[3] 0.51086f
C437 x1.XM1.G0 a_2222_n22299# 0.02161f
C438 x1.xtr.top x1.xres.XR1[2].R1 0.03111f
C439 x1.x1[4].out x1.level_shift_0[4].in_n 0.02132f
C440 a_n973_n22299# x1.XQ2_7.E 0.03529f
C441 x1.level_shift_0[5].in_n trim[6] 0.06148f
C442 x1.vbg x1.xres.c 0.07786f
C443 x1.x1[5].out x1.level_shift_0[4].XM7.G0 0.02224f
C444 x1.level_shift_0[2].out trim[10] 0.06887f
C445 x1.vbg x2.vbn1 0.20626f
C446 x1.level_shift_0[7].XM7.D0 x1.level_shift_0[7].XM7.G0 2.21752f
C447 x1.x1[4].out trim[4] 0.05485f
C448 x1.x1[8].in_n vdd 0.05434f
C449 x1.x1[6].XM7.D0 x1.x1[6].out 2.70804f
C450 x1.x1[7].in_n x1.x1[6].XM7.D0 0.03829f
C451 x1.level_shift_0[2].XM2.D0 x1.level_shift_0[2].in_n 0.13434f
C452 x1.xtr.XM0[15].S a_n2798_n18803# 0.1873f
C453 x1.level_shift_0[0].out x1.level_shift_0[2].in_n 0.01004f
C454 x1.xres.XR1[8].R2 a_731_n22299# 0.02466f
C455 x1.xres.XR1[9].R1 x1.xres.XR1[10].R1 0.24692f
C456 x1.level_shift_0[6].out vdd 0.56946f
C457 x1.level_shift_0[3].XM7.G0 x1.level_shift_0[3].XM2.D0 2.18793f
C458 x1.level_shift_0[1].XM7.D0 x1.level_shift_0[0].XM7.D0 0.0167f
C459 x1.level_shift_0[2].XM7.D0 x1.level_shift_0[2].in_n 0.10509f
C460 x1.level_shift_0[5].XM7.G0 x1.x1[4].out 0.0218f
C461 x1.level_shift_0[0].XM7.D0 trim[14] 0.21012f
C462 x1.XM1.G0 x1.xres.XR1[17].R1 0.15858f
C463 x1.level_shift_0[4].XM7.G0 x1.x1[2].out 0.01062f
C464 x1.XQ2_7.E a_n2798_n16227# 0.02136f
C465 x1.level_shift_0[4].XM7.D0 x1.level_shift_0[3].XM7.D0 0.0167f
C466 a_n1399_n22299# vdd 0.09345f
C467 trim[13] trim[12] 0.02401f
C468 x1.vbg x2.outb1p 5.36394f
C469 x1.vs2 x1.level_shift_0[0].XM7.G0 0.06477f
C470 x1.x1[7].out x1.level_shift_0[7].in_n 0.01143f
C471 x1.x1[8].in_n x1.x1[7].XM7.D0 0.03829f
C472 a_2009_n22299# a_2222_n22299# 0.74283f
C473 x1.level_shift_0[6].out x1.level_shift_0[6].XM7.G0 0.01462f
C474 x1.level_shift_0[2].out trim[4] 0.03839f
C475 x1.XQ2_7.E a_n2798_n14019# 0.03746f
C476 x1.x1[1].out vdd 2.02852f
C477 x1.x1[3].in_n x1.x1[3].XM2.D0 0.20696f
C478 vdd trim[12] 0.48748f
C479 x1.level_shift_0[6].in_n vdd 0.37578f
C480 a_n2798_n15859# a_n2798_n16227# 0.1176f
C481 x1.x1[5].out x1.x1[6].XM7.G0 0.01889f
C482 x1.level_shift_0[7].XM7.G0 trim[0] 0.09307f
C483 x1.level_shift_0[5].XM2.D0 x1.level_shift_0[5].in_n 0.13434f
C484 x1.xtr.top a_92_n22299# 0.01421f
C485 x1.x1[1].in_n vdd 0.06705f
C486 x1.x1[3].XM2.D0 trim[11] 1.37903f
C487 x1.XM1.G0 x1.xamp.vbn1 0.49559f
C488 x1.vbg x2.vbp1 0.04398f
C489 x1.level_shift_0[4].XM7.G0 x1.x1[3].out 0.08646f
C490 x1.xamp.XM6.S0 x1.xamp.XM1.S0 0.02865f
C491 x1.x1[7].out x1.XQ2_7.E 0.40645f
C492 x1.level_shift_0[6].XM7.G0 x1.level_shift_0[6].in_n 1.56081f
C493 x2.outb1p ibias2_1u 0.13158f
C494 a_n2798_n13651# a_n2798_n14019# 0.1176f
C495 x1.level_shift_0[6].XM7.D0 trim[2] 0.21012f
C496 x1.xres.XR1[15].R2 a_2222_n22299# 0.05732f
C497 x1.level_shift_0[7].XM7.D0 vdd 2.69081f
C498 x1.xres.XR1[1].R1 a_n1186_n22299# 0.02471f
C499 x1.vs2 x1.xres.d 0.06839f
C500 x1.XM1.G0 a_n547_n22299# 0.03592f
C501 x1.level_shift_0[0].out trim[6] 0.01848f
C502 x1.level_shift_0[1].XM7.D0 x1.level_shift_0[1].XM7.G0 2.21752f
C503 x1.x1[7].XM7.D0 x1.level_shift_0[6].in_n 0.08111f
C504 x1.xamp.vbp2 x1.xamp.XM8.S1 6.0598f
C505 x1.xres.c x1.XQ2_7.E 0.54322f
C506 x1.vbg x1.XM1.S0 0.87251f
C507 x1.x1[1].out x1.level_shift_0[0].XM7.D0 0.23494f
C508 x1.x1[2].XM7.D0 vdd 2.70493f
C509 x1.level_shift_0[0].XM7.D0 trim[12] 0.03336f
C510 x1.XM1.G0 ibias1_250n 2.64193f
C511 x1.XM1.G0 x1.xamp.out1p 10.7684f
C512 x1.x1[7].out x1.level_shift_0[6].out 0.31776f
C513 x1.x1[2].out trim[8] 0.01187f
C514 x1.level_shift_0[3].XM7.G0 vdd 2.56144f
C515 x1.level_shift_0[7].XM7.G0 x1.level_shift_0[6].XM7.D0 0.01219f
C516 x1.level_shift_0[4].XM7.D0 x1.x1[4].out 0.04428f
C517 x1.level_shift_0[1].XM7.D0 x1.level_shift_0[1].out 2.70564f
C518 x1.x1[6].XM7.D0 x1.x1[6].in_n 0.01441f
C519 x1.XM1.G0 x1.xamp.out1n 3.28521f
C520 x2.vbp1 ibias2_1u 0.04457f
C521 x1.vs2 a_3074_n22299# 0.1454f
C522 x1.XM1.G0 a_518_n22299# 0.02161f
C523 x1.level_shift_0[5].in_n x1.level_shift_0[3].out 0.06187f
C524 x1.XQ2_7.E x1.xtr.XM0[5].S 0.30307f
C525 x1.x1[8].out x1.level_shift_0[7].XM7.G0 0.1045f
C526 x1.level_shift_0[4].XM2.D0 x1.level_shift_0[1].out 0.01113f
C527 x1.XM1.G0 x1.xamp.vbn2 10.4408f
C528 x1.level_shift_0[2].XM7.G0 x1.level_shift_0[1].out 0.04391f
C529 x1.xres.XR1[11].R2 a_1157_n22299# 0.06253f
C530 x1.level_shift_0[4].out trim[4] 0.08342f
C531 x1.XQ2_7.E x1.level_shift_0[1].out 0.40852f
C532 x1.x1[0].XM7.G0 vdd 2.53592f
C533 vdd trim[0] 0.39841f
C534 x1.x1[2].in_n trim[13] 0.68648f
C535 x1.level_shift_0[3].XM7.D0 x1.x1[2].out 0.02795f
C536 x1.x1[7].out x1.level_shift_0[6].in_n 0.02453f
C537 x1.x1[5].in_n trim[7] 0.49215f
C538 x1.vbg ibias2_1u 0.73807f
C539 x1.xtr.XM0[6].S a_n2798_n15491# 0.1873f
C540 x1.level_shift_0[5].XM7.G0 x1.level_shift_0[4].out 0.04596f
C541 x1.level_shift_0[1].in_n vdd 0.38912f
C542 x2.outa1n vdd 21.676f
C543 x1.xtr.top a_1157_n22299# 0.01322f
C544 x1.level_shift_0[4].XM7.D0 x1.level_shift_0[2].out 0.04018f
C545 x1.vs2 a_1796_n22299# 0.01238f
C546 x1.x1[1].XM2.D0 x1.x1[1].XM7.G0 2.1839f
C547 x1.x1[2].in_n vdd 0.05434f
C548 x1.x1[3].out trim[8] 0.01673f
C549 x1.x1[8].XM7.D0 vdd 2.69434f
C550 x1.vs2 vdd 5.95685f
C551 x1.XM1.G0 x1.ena_b_h 2.43884f
C552 a_2435_n22299# x1.xres.c 0.01252f
C553 x1.XM1.G0 x1.xres.XR1[9].R1 0.15825f
C554 x1.xres.XR1[15].R2 x1.xres.XR1[16].R2 0.19948f
C555 x1.level_shift_0[6].in_n x1.level_shift_0[5].XM7.D0 0.05008f
C556 x2.outa1p x2.diffa 3.63632f
C557 x1.x1[1].out x1.level_shift_0[1].XM7.G0 0.07164f
C558 x1.vs2 a_n973_n22299# 0.01479f
C559 x1.level_shift_0[1].XM7.G0 trim[12] 0.09307f
C560 a_1370_n22299# a_1157_n22299# 0.74283f
C561 x1.XQ2_7.E x1.x1[6].out 0.40695f
C562 x2.XMB4.S0 x2.outa1n 0.20697f
C563 x1.xamp.XM6.S0 x1.xamp.vbp1 0.16501f
C564 x1.level_shift_0[0].in_n x1.ena_b_h 0.05489f
C565 x1.level_shift_0[3].XM7.D0 x1.x1[3].out 0.04308f
C566 x1.x1[4].XM2.D0 trim[9] 1.3785f
C567 x1.level_shift_0[6].XM7.D0 vdd 2.70116f
C568 x1.x1[5].out x1.x1[4].out 0.06128f
C569 x1.XM1.S0 x1.XQ2_7.E 0.04158f
C570 x1.xamp.XM6.S0 x1.xamp.vbp2 8.61634f
C571 x1.level_shift_0[1].out trim[12] 0.06887f
C572 x1.vbg x1.XQ2_7.E 0.13885f
C573 x1.level_shift_0[1].in_n x1.level_shift_0[0].XM7.D0 0.05008f
C574 x1.xres.XR1[2].R1 x1.xres.XR1[5].R1 0.02835f
C575 a_n760_n22299# a_n547_n22299# 0.74283f
C576 x1.x1[8].out vdd 0.80643f
C577 x1.vs2 x1.level_shift_0[0].XM7.D0 0.02569f
C578 x1.x1[1].XM7.D0 trim[14] 0.27036f
C579 x1.x1[7].XM7.G0 trim[1] 0.01658f
C580 x1.level_shift_0[5].XM7.G0 trim[4] 0.09307f
C581 x1.level_shift_0[6].XM7.D0 x1.level_shift_0[6].XM7.G0 2.21752f
C582 x1.x1[0].in_p ena 0.62594f
C583 a_2009_n22299# x1.ena_b_h 0.01555f
C584 a_1370_n22299# x1.xres.XR1[11].R2 0.05732f
C585 x1.x1[3].XM7.G0 trim[9] 0.02238f
C586 x1.level_shift_0[7].out x1.XQ2_7.E 0.41897f
C587 x1.x1[7].XM7.D0 x1.level_shift_0[6].XM7.D0 0.01364f
C588 a_3287_n22299# x1.ena_b_h 0.05443f
C589 x1.level_shift_0[2].in_n vdd 0.38896f
C590 x1.level_shift_0[4].XM7.D0 x1.level_shift_0[4].out 2.65837f
C591 x1.xres.XR1[6].R1 a_n121_n22299# 0.05152f
C592 x1.level_shift_0[5].in_n x1.x1[6].XM7.G0 0.20038f
C593 x1.xtr.top a_1370_n22299# 0.01527f
C594 x2.outa1p x2.XM9.D0_0 28.8852f
C595 a_n760_n22299# x1.xres.XR1[3].R2 0.05732f
C596 x1.x1[5].in_n x1.x1[4].XM7.D0 0.03829f
C597 x1.x1[6].out x1.level_shift_0[6].in_n 0.0378f
C598 x1.x1[7].in_n x1.level_shift_0[6].in_n 0.48652f
C599 x1.xtr.top x1.XQ2_7.E 0.3531f
C600 x1.XQ2_7.E x1.xtr.XM0[11].S 0.30301f
C601 x1.level_shift_0[3].XM7.G0 x1.level_shift_0[1].out 0.01584f
C602 x2.outa1p x2.XMOP.G0_0 3.97396f
C603 x1.x1[1].out x1.vbg 0.01322f
C604 x1.x1[1].XM2.D0 trim[15] 1.37837f
C605 x1.x1[4].out x1.x1[3].out 0.06128f
C606 x1.vs2 x1.xres.c 0.07521f
C607 x1.level_shift_0[1].in_n x1.level_shift_0[1].XM7.G0 1.56081f
C608 x2.diffa vbg 3.39858f
C609 x1.xtr.XM0[9].S a_n2798_n16595# 0.1873f
C610 x2.outb1n x2.diffa 0.33437f
C611 x1.xtr.top x1.xres.XR1[13].R1 0.06227f
C612 x1.level_shift_0[0].XM7.G0 x1.level_shift_0[0].in_n 1.56081f
C613 x1.level_shift_0[2].XM7.G0 x1.level_shift_0[1].XM7.D0 0.01219f
C614 x1.x1[7].out x1.level_shift_0[6].XM7.D0 0.24855f
C615 x1.x1[8].in_n x1.level_shift_0[7].in_n 0.45991f
C616 x1.x1[5].XM2.D0 vdd 1.28662f
C617 x1.x1[1].out x1.x1[1].XM7.D0 2.71719f
C618 x1.vs2 a_92_n22299# 0.01238f
C619 x1.level_shift_0[7].in_n x1.level_shift_0[6].out 0.04375f
C620 x1.level_shift_0[4].XM7.D0 x1.level_shift_0[4].in_n 0.10509f
C621 x1.x1[8].out x1.x1[7].out 0.06132f
C622 x2.outb1p x2.outa1n 0.82263f
C623 x1.xtr.top a_n1399_n22299# 0.06915f
C624 x1.level_shift_0[4].out x1.level_shift_0[6].XM2.D0 0.05338f
C625 x1.level_shift_0[6].XM7.D0 x1.level_shift_0[5].XM7.D0 0.0167f
C626 x1.level_shift_0[4].XM7.D0 trim[4] 0.03336f
C627 vdd trim[6] 0.46633f
C628 x1.xtr.XM0[3].S a_n2798_n14387# 0.1873f
C629 x1.x1[3].out x1.level_shift_0[2].out 1.72923f
C630 x1.xres.XR1[13].R1 a_1370_n22299# 0.02471f
C631 x1.x1[1].in_n x1.x1[1].XM7.D0 0.01441f
C632 x1.xtr.top x1.x1[1].out 0.14324f
C633 x1.x1[5].out x1.level_shift_0[4].out 1.00787f
C634 x1.xtr.top a_2435_n22299# 0.01326f
C635 a_305_n22299# a_518_n22299# 0.74283f
C636 x1.xamp.vbp1 x1.xamp.XM1.S0 3.45317f
C637 x1.x1[4].in_n x1.x1[3].XM7.D0 0.03829f
C638 x1.XQ2_7.E a_n2798_n15859# 0.02136f
C639 x1.level_shift_0[5].XM7.G0 x1.level_shift_0[4].XM7.D0 0.01219f
C640 x1.level_shift_0[7].XM7.D0 x1.level_shift_0[7].out 2.70139f
C641 x1.x1[5].XM7.D0 x1.level_shift_0[4].in_n 0.08111f
C642 x1.x1[5].out x1.xtr.XM0[8].S 0.1383f
C643 x1.XQ2_7.E x1.level_shift_0[6].out 0.40659f
C644 x1.x1[8].XM7.G0 x1.x1[8].XM2.D0 2.1839f
C645 x1.XM1.G0 x1.xamp.XM8.D0 9.90496f
C646 x1.xamp.vbp2 x1.xamp.XM1.S0 0.01125f
C647 x1.x1[7].XM7.G0 trim[2] 0.18812f
C648 x1.xtr.XM0[15].S x1.level_shift_0[0].out 0.14052f
C649 x1.XQ2_7.E a_n2798_n13651# 0.14654f
C650 x1.x1[4].XM7.G0 trim[7] 0.01658f
C651 x1.x1[7].out x1.xtr.XM0[4].S 0.13722f
C652 x2.outa1n x2.vbp1 0.13695f
C653 x1.level_shift_0[3].in_n trim[8] 2.83612f
C654 x1.XM1.G0 a_3074_n22299# 0.022f
C655 x1.x1[1].out x1.level_shift_0[1].XM7.D0 0.01027f
C656 a_n1399_n22299# x1.XQ2_7.E 0.10754f
C657 x2.XM9.D0_0 vbg 0.07461f
C658 x1.x1[1].out trim[14] 0.1643f
C659 x1.level_shift_0[1].XM7.D0 trim[12] 0.21012f
C660 x1.level_shift_0[0].out trim[8] 0.01192f
C661 x2.outb1n x2.XM9.D0_0 3.59829f
C662 x1.x1[0].XM7.G0 ena 1.49117f
C663 x1.level_shift_0[2].XM7.D0 trim[8] 0.03336f
C664 x1.x1[3].XM2.D0 vdd 1.28662f
C665 x1.xres.XR1[7].R2 a_518_n22299# 0.05732f
C666 x1.xtr.top x1.xres.XR1[18].R1 0.06194f
C667 x1.x1[1].out x1.level_shift_0[2].XM7.G0 0.06085f
C668 x1.level_shift_0[7].XM7.D0 x1.level_shift_0[7].in_n 0.10509f
C669 x1.x1[1].out x1.XQ2_7.E 0.33974f
C670 x1.level_shift_0[5].XM2.D0 vdd 1.28659f
C671 x1.level_shift_0[4].out x1.xtr.XM0[7].S 0.13803f
C672 x1.vbg x2.outa1n 3.14318f
C673 x1.x1[3].XM7.D0 trim[10] 0.27036f
C674 x1.vs2 a_1157_n22299# 0.01277f
C675 x1.x1[2].XM7.G0 x1.x1[2].out 0.03016f
C676 x2.XMOP.G0_0 vbg 1.35038p
C677 x1.XM1.G0 a_1796_n22299# 0.02138f
C678 x1.vs2 x1.XM1.S0 0.07456f
C679 x1.x1[1].in_n trim[14] 0.13186f
C680 x1.level_shift_0[3].XM7.D0 x1.level_shift_0[3].in_n 0.10509f
C681 x1.x1[2].out trim[10] 0.01432f
C682 x1.xtr.XM0[7].S x1.xtr.XM0[8].S 0.14646f
C683 x1.level_shift_0[7].out trim[0] 0.07133f
C684 x2.outb1n x2.XMOP.G0_0 17.7972f
C685 x1.vbg x1.vs2 0.35844f
C686 x1.xamp.XM8.S1 x1.xamp.out1p 0.05821f
C687 x1.x1[5].out x1.level_shift_0[4].in_n 0.02949f
C688 x1.level_shift_0[5].in_n x1.x1[4].out 0.013f
C689 x1.XM1.G0 vdd 7.3551f
C690 x1.x1[4].XM7.G0 trim[8] 0.15935f
C691 x1.xtr.top a_n334_n22299# 0.0194f
C692 x1.level_shift_0[0].out x1.level_shift_0[3].XM7.D0 0.02576f
C693 x1.level_shift_0[2].in_n x1.level_shift_0[1].out 0.04815f
C694 x1.xtr.XM0[11].S a_n2798_n17699# 0.19209f
C695 x1.level_shift_0[0].in_n trim[13] 0.01542f
C696 x1.xamp.XM8.S1 x1.xamp.out1n 0.35528f
C697 x1.x1[5].out trim[4] 0.12456f
C698 x1.xtr.XM0[4].S x1.xtr.XM0[5].S 0.14646f
C699 x1.level_shift_0[2].XM7.D0 x1.level_shift_0[3].XM7.D0 0.0167f
C700 x1.XM1.G0 a_n973_n22299# 0.04764f
C701 x1.x1[2].in_n x1.x1[1].XM7.D0 0.03829f
C702 x1.x1[2].XM7.D0 x1.level_shift_0[1].XM7.D0 0.01364f
C703 x1.level_shift_0[0].in_n vdd 0.63986f
C704 x1.x1[4].XM7.D0 x1.level_shift_0[3].in_n 0.08111f
C705 x1.xtr.XM0[1].S x1.xtr.XM0[2].S 0.14646f
C706 x1.level_shift_0[5].XM7.G0 x1.x1[5].out 0.10153f
C707 x1.vs2 x1.xres.XR1[11].R2 0.01656f
C708 x2.outa1n ibias2_1u 0.02184f
C709 x1.level_shift_0[7].in_n trim[0] 2.9905f
C710 a_3074_n22299# a_3287_n22299# 0.74283f
C711 x1.level_shift_0[4].in_n trim[5] 0.01542f
C712 x1.xtr.top x1.xres.XR1[5].R1 0.06295f
C713 x1.x1[3].out trim[10] 0.16552f
C714 x1.xtr.top a_n2798_n19171# 0.19529f
C715 trim[5] trim[4] 0.02341f
C716 x1.XQ2_7.E a_n2798_n17699# 0.02136f
C717 x1.x1[2].XM7.G0 x1.x1[2].XM2.D0 2.1839f
C718 x1.x1[5].XM7.D0 x1.x1[6].XM2.D0 0.04515f
C719 x1.x1[1].XM7.G0 x1.ena_b_h 0.02556f
C720 x1.x1[1].out trim[12] 0.01559f
C721 x1.xres.XR1[14].R1 x1.xres.XR1[17].R1 0.02835f
C722 a_1796_n22299# a_2009_n22299# 0.74283f
C723 x1.XM1.G0 x1.xres.XR1[2].R1 0.05418f
C724 x1.level_shift_0[3].out vdd 0.5818f
C725 x1.x1[8].XM7.D0 x1.level_shift_0[7].in_n 0.08111f
C726 x1.x1[4].XM7.G0 x1.x1[4].XM7.D0 2.21217f
C727 x1.xres.XR1[10].R1 a_1157_n22299# 0.05172f
C728 x1.xres.XR1[7].R2 x1.xres.XR1[8].R2 0.19948f
C729 x1.xtr.XM0[5].S a_n2798_n15491# 0.19209f
C730 x1.x1[7].XM7.G0 vdd 2.56202f
C731 x1.xamp.vbp1 x1.xamp.vbp2 6.93945f
C732 x1.x1[5].XM7.D0 x1.level_shift_0[4].XM7.D0 0.01364f
C733 x1.level_shift_0[1].in_n x1.level_shift_0[1].XM7.D0 0.10509f
C734 x1.x1[8].out x1.level_shift_0[7].out 0.61001f
C735 x1.xamp.vbn1 x1.xamp.XM6.S0 0.04198f
C736 x1.level_shift_0[1].in_n trim[14] 0.06148f
C737 x1.level_shift_0[0].XM7.D0 x1.level_shift_0[0].in_n 0.10509f
C738 x1.level_shift_0[1].out trim[6] 0.01627f
C739 x1.x1[4].out x1.level_shift_0[3].in_n 0.0336f
C740 x1.level_shift_0[4].in_n x1.x1[3].out 0.01046f
C741 a_2861_n22299# x1.ena_b_h 0.03733f
C742 x1.vs2 trim[14] 0.09417f
C743 x1.vs2 a_1370_n22299# 0.01238f
C744 x1.xtr.top a_731_n22299# 0.01326f
C745 x1.level_shift_0[7].in_n x1.level_shift_0[6].XM7.D0 0.05008f
C746 a_n2798_n19171# x1.XQ2_7.E 0.02979f
C747 x1.xres.XR1[18].R1 a_2435_n22299# 0.05152f
C748 x1.x1[8].in_n trim[0] 0.11972f
C749 x1.x1[5].XM7.G0 x1.x1[5].XM2.D0 2.1839f
C750 a_1796_n22299# x1.xres.XR1[15].R2 0.05732f
C751 x1.vs2 x1.XQ2_7.E 0.30448f
C752 x1.x1[5].out x1.x1[6].XM2.D0 0.03292f
C753 x1.level_shift_0[3].XM2.D0 trim[8] 1.35191f
C754 x1.xamp.XM6.S0 ibias1_250n 0.04535f
C755 x1.x1[7].XM7.G0 x1.x1[7].XM7.D0 2.21217f
C756 x1.xamp.XM6.S0 x1.xamp.out1p 3.2453f
C757 x1.level_shift_0[6].out trim[0] 0.10098f
C758 x1.level_shift_0[5].XM2.D0 x1.level_shift_0[5].XM7.D0 0.05094f
C759 x1.x1[2].XM7.D0 trim[12] 0.27036f
C760 x1.x1[5].in_n x1.level_shift_0[4].in_n 0.45885f
C761 x1.x1[8].out x1.level_shift_0[7].in_n 0.06111f
C762 x1.x1[1].out x1.level_shift_0[3].XM7.G0 0.07967f
C763 x1.x1[0].XM7.D0 trim[15] 0.08381f
C764 x1.x1[4].XM7.G0 x1.x1[4].out 0.02972f
C765 x1.xamp.XM6.S0 x1.xamp.out1n 6.13075f
C766 x1.x1[8].XM7.D0 x1.x1[8].in_n 0.01441f
C767 x1.x1[5].out x1.level_shift_0[4].XM7.D0 0.15861f
C768 x1.level_shift_0[4].XM7.G0 vdd 2.56144f
C769 x1.x1[5].XM7.G0 trim[6] 0.18059f
C770 x1.level_shift_0[3].in_n x1.level_shift_0[2].out 0.04588f
C771 x1.level_shift_0[2].in_n x1.x1[3].XM7.G0 0.20038f
C772 x1.xtr.top x1.xres.XR1[10].R1 0.02816f
C773 x1.xamp.XM6.S0 x1.xamp.vbn2 2.51545f
C774 x1.xtr.XM0[10].S x1.xtr.XM0[11].S 0.14646f
C775 x1.level_shift_0[5].in_n x1.level_shift_0[4].out 0.10712f
C776 x1.XM1.G0 a_92_n22299# 0.02138f
C777 a_n973_n22299# a_n760_n22299# 0.74283f
C778 x1.level_shift_0[3].XM7.D0 x1.level_shift_0[3].XM2.D0 0.05094f
C779 x1.level_shift_0[2].XM7.D0 x1.level_shift_0[2].out 2.69056f
C780 x1.vs2 a_n1399_n22299# 0.08043f
C781 x1.x1[6].XM2.D0 trim[5] 1.37999f
C782 x2.diffa vdd 0.15602f
C783 x1.x1[5].XM7.D0 x1.x1[5].out 2.70986f
C784 x1.level_shift_0[2].in_n trim[9] 0.01542f
C785 x1.x1[8].out x1.XQ2_7.E 0.41299f
C786 x1.x1[3].in_n trim[10] 0.12405f
C787 x2.outa1p x2.vbn2 5.29385f
C788 x1.x1[1].out x1.level_shift_0[1].in_n 0.02255f
C789 x1.level_shift_0[2].in_n x1.level_shift_0[1].XM7.D0 0.05008f
C790 x1.level_shift_0[1].in_n trim[12] 2.79393f
C791 x1.x1[7].XM7.G0 x1.x1[7].out 0.0292f
C792 x1.x1[1].out x1.vs2 0.01199f
C793 x1.xamp.XM6.S0 x1.ena_b_h 0.05218f
C794 x1.x1[2].in_n trim[12] 0.13286f
C795 x1.level_shift_0[6].XM7.D0 x1.level_shift_0[6].out 2.66617f
C796 x1.level_shift_0[5].out trim[4] 0.06886f
C797 x1.vs2 a_2435_n22299# 0.05649f
C798 x1.level_shift_0[2].XM7.G0 x1.level_shift_0[2].in_n 1.56081f
C799 x1.x1[6].XM7.G0 vdd 2.56202f
C800 x1.level_shift_0[3].out x1.level_shift_0[5].XM7.D0 0.0121f
C801 x1.XQ2_7.E x1.xtr.XM0[10].S 0.30301f
C802 a_2009_n22299# x1.xres.c 0.011f
C803 x1.xres.XR1[2].R1 a_n760_n22299# 0.0564f
C804 x1.level_shift_0[7].XM7.D0 trim[0] 0.21012f
C805 x1.level_shift_0[5].out x1.level_shift_0[5].XM7.G0 0.01039f
C806 x1.x1[2].XM7.G0 trim[11] 0.01658f
C807 trim[11] trim[10] 0.02338f
C808 x1.x1[8].out x1.level_shift_0[6].out 0.10266f
C809 x1.x1[4].in_n x1.level_shift_0[3].in_n 0.44564f
C810 x1.x1[5].XM7.D0 trim[5] 0.07792f
C811 x1.level_shift_0[5].XM2.D0 x1.x1[6].out 0.01023f
C812 x1.XQ2_7.E x1.xtr.XM0[4].S 0.30477f
C813 x1.xtr.XM0[13].S a_n2798_n18435# 0.19209f
C814 x1.xres.XR1[13].R1 x1.xres.XR1[10].R1 0.02835f
C815 x1.level_shift_0[4].XM7.D0 x1.x1[3].out 0.07697f
C816 x1.xtr.XM0[8].S a_n2798_n16595# 0.19209f
C817 x1.x1[8].XM7.D0 x1.level_shift_0[7].XM7.D0 0.01364f
C818 x1.level_shift_0[6].XM7.D0 x1.level_shift_0[6].in_n 0.10509f
C819 x1.level_shift_0[5].in_n trim[4] 2.85732f
C820 vdd trim[8] 0.46633f
C821 x1.level_shift_0[1].in_n x1.x1[2].XM7.D0 0.08111f
C822 x1.xtr.XM0[12].S x1.xtr.XM0[13].S 0.14646f
C823 x1.x1[2].XM7.D0 x1.x1[2].in_n 0.01441f
C824 x1.XM1.G0 a_1157_n22299# 0.02162f
C825 x1.xres.XR1[5].R1 a_n334_n22299# 0.02471f
C826 x1.level_shift_0[5].XM7.G0 x1.level_shift_0[5].in_n 1.56081f
C827 x1.xres.XR1[15].R2 x1.xres.c 0.01617f
C828 x1.x1[4].out x1.level_shift_0[3].XM2.D0 0.01256f
C829 x1.XM1.G0 x1.XM1.S0 1.67707f
C830 x2.XM9.D0_0 vdd 34.8482f
C831 x1.x1[4].XM7.G0 x1.x1[4].in_n 1.46694f
C832 x1.vbg x1.XM1.G0 1.40771f
C833 x1.vs2 a_n334_n22299# 0.01244f
C834 a_2861_n22299# x1.xres.d 0.02466f
C835 x1.xamp.XM8.S1 x1.xamp.XM8.D0 31.0009f
C836 x1.xtr.XM0[2].S a_n2798_n14387# 0.19209f
C837 x1.level_shift_0[3].XM7.D0 vdd 2.70116f
C838 x1.level_shift_0[7].XM7.D0 x1.level_shift_0[6].XM7.D0 0.0167f
C839 x1.level_shift_0[3].in_n trim[10] 0.06148f
C840 x1.x1[1].out x1.level_shift_0[2].in_n 0.01086f
C841 x2.XMOP.G0_0 vdd 19.5842f
C842 x1.level_shift_0[2].in_n trim[12] 0.06148f
C843 x1.XQ2_7.E a_n2798_n15491# 0.02136f
C844 x1.xamp.XM1.S0 x1.xamp.out1p 11.3804f
C845 x1.level_shift_0[4].XM2.D0 trim[6] 1.35191f
C846 x1.level_shift_0[2].XM2.D0 trim[10] 1.35191f
C847 x1.level_shift_0[0].out trim[10] 0.01151f
C848 x1.x1[8].out x1.level_shift_0[7].XM7.D0 0.21472f
C849 x1.x1[8].XM7.D0 trim[0] 0.27036f
C850 x1.x1[3].XM7.G0 x1.x1[3].XM2.D0 2.1839f
C851 x1.level_shift_0[2].XM7.D0 trim[10] 0.21012f
C852 x1.xamp.XM1.S0 x1.xamp.out1n 6.82446f
C853 x1.XQ2_7.E x1.xtr.XM0[14].S 0.30407f
C854 x2.XMB4.S0 x2.XM9.D0_0 0.04657f
C855 x1.x1[1].XM7.G0 trim[13] 0.08441f
C856 x1.x1[5].XM7.D0 x1.x1[5].in_n 0.01441f
C857 x1.level_shift_0[3].XM2.D0 x1.level_shift_0[2].out 0.06367f
C858 x1.x1[4].XM7.D0 vdd 2.70469f
C859 x2.vbn2 vbg 0.03867f
C860 x1.level_shift_0[1].in_n x1.x1[2].in_n 0.43929f
C861 x2.diffa x2.vbn1 1.90994f
C862 x1.x1[7].XM7.G0 x1.x1[7].in_n 1.46749f
C863 x1.x1[7].XM7.G0 x1.x1[6].out 0.01904f
C864 a_n2798_n15491# a_n2798_n15859# 0.1176f
C865 x2.outb1n x2.vbn2 6.75452f
C866 x1.xamp.XM1.S0 x1.xamp.vbn2 2.48831f
C867 a_2861_n22299# a_3074_n22299# 0.74283f
C868 x1.level_shift_0[4].XM7.G0 x1.level_shift_0[1].out 0.05343f
C869 x1.x1[1].XM7.D0 x1.level_shift_0[0].in_n 0.08111f
C870 a_2648_n22299# x1.ena_b_h 0.03021f
C871 x1.x1[1].XM7.G0 vdd 2.57961f
C872 x1.xamp.XM8.S1 vdd 8.87628f
C873 x2.XMB4.S0 x2.XMOP.G0_0 0.011f
C874 x1.xtr.top x1.XM1.G0 2.98406f
C875 x1.x1[0].XM7.D0 x1.x1[0].XM2.D0 0.04751f
C876 a_n2798_n14387# a_n2798_n14755# 0.1176f
C877 x1.level_shift_0[6].XM7.D0 trim[0] 0.03336f
C878 a_n2798_n18803# a_n2798_n18435# 0.1176f
C879 x1.ena_b_h x2.vbn2 0.45068f
C880 x1.level_shift_0[5].in_n x1.x1[6].XM2.D0 0.01864f
C881 x1.x1[6].XM7.G0 trim[3] 0.01658f
C882 x2.outb1p x2.diffa 0.01898f
C883 x1.x1[8].out trim[0] 0.16249f
C884 x1.vs2 a_731_n22299# 0.01392f
C885 x1.x1[3].XM7.D0 x1.x1[3].out 2.71349f
C886 x1.vs2 x1.xres.XR1[4].R2 0.03012f
C887 x1.xtr.XM0[11].S a_n2798_n17331# 0.1873f
C888 x2.diffb vbg 4.16673f
C889 x1.XM1.G0 a_1370_n22299# 0.02161f
C890 x1.x1[3].out x1.x1[2].out 0.06143f
C891 x1.level_shift_0[5].in_n x1.level_shift_0[4].XM7.D0 0.05008f
C892 x2.outb1n x2.diffb 7.73164f
C893 x1.x1[4].out vdd 0.92595f
C894 x1.level_shift_0[1].XM2.D0 x1.x1[2].out 0.01644f
C895 x1.level_shift_0[0].XM2.D0 x1.ena_b_h 0.06162f
C896 x1.x1[6].XM7.G0 x1.x1[6].XM7.D0 2.21217f
C897 x1.XM1.G0 x1.XQ2_7.E 1.0092f
C898 x1.x1[8].XM7.D0 x1.x1[8].out 2.70457f
C899 x1.ena_b_h x1.x1[0].XM2.D0 0.10194f
C900 x1.level_shift_0[0].in_n trim[14] 2.7835f
C901 x1.xamp.XM6.S0 x1.xamp.XM8.D0 10.9293f
C902 x1.level_shift_0[4].out trim[2] 0.04892f
C903 x1.xres.XR1[6].R1 x1.xres.XR1[9].R1 0.02835f
C904 a_92_n22299# a_305_n22299# 0.74283f
C905 x1.ena_b_h x2.diffb 0.24288f
C906 x1.xtr.top a_2009_n22299# 0.01322f
C907 x1.level_shift_0[5].out x1.level_shift_0[6].XM2.D0 0.05321f
C908 x2.XM9.D0_0 x2.vbn1 0.03091f
C909 x1.XM1.G0 x1.xres.XR1[13].R1 0.15823f
C910 x1.XQ2_7.E a_n2798_n17331# 0.02136f
C911 x1.level_shift_0[1].out trim[8] 0.01215f
C912 x1.xamp.vbp1 ibias1_250n 0.09162f
C913 x1.level_shift_0[2].out vdd 0.57197f
C914 x2.XMOP.G0_0 x2.vbn1 0.04015f
C915 x1.xtr.XM0[5].S a_n2798_n15123# 0.1873f
C916 x1.xamp.vbp2 ibias1_250n 2.72678f
C917 a_1583_n22299# a_1796_n22299# 0.74283f
C918 x1.vbg x2.diffa 2.83482f
C919 x1.xamp.vbp2 x1.xamp.out1p 3.67561f
C920 x1.XM1.G0 a_n1399_n22299# 0.07692f
C921 x1.level_shift_0[4].XM2.D0 x1.level_shift_0[3].out 0.05679f
C922 x2.outb1p x2.XM9.D0_0 21.3443f
C923 x1.x1[6].XM7.G0 x1.x1[6].out 0.02938f
C924 x1.xres.XR1[10].R1 a_731_n22299# 0.05152f
C925 x1.level_shift_0[3].out x1.XQ2_7.E 0.40723f
C926 a_92_n22299# x1.xres.XR1[7].R2 0.05732f
C927 x1.xamp.vbp1 x1.xamp.vbn2 4.71134f
C928 x1.xamp.vbp2 x1.xamp.out1n 0.09234f
C929 x1.xamp.XM6.S0 vdd 34.9848f
C930 x1.level_shift_0[3].XM7.D0 x1.level_shift_0[1].out 0.0294f
C931 x1.xtr.XM0[13].S a_n2798_n18067# 0.1873f
C932 x1.XM1.G0 a_2435_n22299# 0.02137f
C933 x1.xamp.vbp2 x1.xamp.vbn2 0.46126f
C934 x1.x1[5].out x1.level_shift_0[5].in_n 0.04894f
C935 x2.outb1p x2.XMOP.G0_0 3.89129f
C936 x1.xtr.top a_n760_n22299# 0.02314f
C937 a_n2798_n16595# a_n2798_n16963# 0.1176f
C938 x1.x1[8].XM2.D0 trim[1] 1.37687f
C939 x1.x1[1].out x1.level_shift_0[0].in_n 0.04904f
C940 x1.xres.XR1[14].R1 a_1796_n22299# 0.0564f
C941 x1.x1[3].XM7.D0 x1.x1[3].in_n 0.01441f
C942 x1.level_shift_0[0].XM7.G0 x1.level_shift_0[0].XM2.D0 2.18793f
C943 x1.x1[4].in_n vdd 0.05434f
C944 x1.x1[2].XM7.D0 x1.x1[3].XM2.D0 0.04515f
C945 x1.ena_b_h x1.xamp.vbp2 4.59556f
C946 x1.XM1.G0 x1.xres.XR1[18].R1 0.05057f
C947 x1.x1[1].XM2.D0 x1.x1[0].XM7.D0 0.04515f
C948 x1.x1[3].out x1.xtr.XM0[12].S 0.13883f
C949 x1.x1[1].in_n x1.level_shift_0[0].in_n 0.44859f
C950 a_n1186_n22299# vdd 0.01279f
C951 x1.level_shift_0[4].XM7.G0 x1.level_shift_0[4].XM2.D0 2.18793f
C952 x2.XMOP.G0_0 x2.vbp1 0.02083f
C953 x1.xres.c x1.xres.XR1[12].R2 0.01774f
C954 a_n760_n22299# x1.XQ2_7.E 0.02121f
C955 x1.level_shift_0[4].out vdd 0.59475f
C956 x1.xres.d x1.xamp.XM1.S0 5.69111f
C957 x1.xres.XR1[17].R1 a_2222_n22299# 0.02471f
C958 x1.XM1.G0 a_n334_n22299# 0.0328f
C959 a_n1186_n22299# a_n973_n22299# 0.74283f
C960 x1.x1[7].XM7.G0 x1.level_shift_0[6].in_n 0.2007f
C961 x1.xtr.XM0[15].S x1.xtr.top 0.15821f
C962 x1.x1[2].XM7.G0 vdd 2.56202f
C963 vdd trim[10] 0.49935f
C964 x1.XQ2_7.E x1.xtr.XM0[9].S 0.30301f
C965 x1.xtr.top a_305_n22299# 0.01322f
C966 a_n2798_n17331# a_n2798_n17699# 0.1176f
C967 x1.x1[6].XM7.G0 x1.x1[6].in_n 1.46694f
C968 x1.x1[1].XM2.D0 x1.ena_b_h 0.04474f
C969 a_1583_n22299# x1.xres.c 0.01252f
C970 x1.XQ2_7.E x1.xtr.XM0[3].S 0.30627f
C971 x1.XM1.G0 x1.xres.XR1[5].R1 0.15913f
C972 x1.x1[4].XM7.D0 x1.x1[4].XM2.D0 0.04746f
C973 trim[9] trim[8] 0.02303f
C974 x1.xtr.XM0[8].S a_n2798_n16227# 0.1873f
C975 x1.x1[7].XM2.D0 vdd 1.28662f
C976 x1.level_shift_0[3].in_n x1.x1[2].out 0.01012f
C977 x1.XM1.G0 x1.vs2 2.87899f
C978 x1.level_shift_0[7].XM7.G0 x1.level_shift_0[7].XM2.D0 2.18793f
C979 x1.xtr.XM0[15].S x1.XQ2_7.E 0.30513f
C980 x1.level_shift_0[3].out x1.level_shift_0[3].XM7.G0 0.01034f
C981 x1.level_shift_0[4].in_n vdd 0.3759f
C982 x1.x1[5].XM7.G0 x1.x1[4].out 0.01873f
C983 x1.level_shift_0[0].out x1.x1[2].out 1.32247f
C984 x1.level_shift_0[2].XM2.D0 x1.x1[2].out 0.02041f
C985 x1.level_shift_0[2].XM7.D0 x1.x1[3].XM7.D0 0.01364f
C986 x2.vbn2 vdd 2.31735f
C987 vdd trim[4] 0.46633f
C988 x1.level_shift_0[2].XM7.D0 x1.x1[2].out 0.03471f
C989 x1.xamp.XM1.S0 vdd 23.8181f
C990 x1.x1[1].XM7.G0 x1.x1[1].XM7.D0 2.21217f
C991 x1.vs2 x1.level_shift_0[0].in_n 0.09484f
C992 x1.xtr.XM0[3].S x1.level_shift_0[6].out 0.13736f
C993 x1.x1[8].XM7.G0 vdd 2.5609f
C994 x1.XM1.G0 a_731_n22299# 0.02137f
C995 x1.xtr.XM0[2].S a_n2798_n14019# 0.1873f
C996 x1.xres.XR1[1].R1 x1.xres.XR1[2].R1 0.24692f
C997 x1.level_shift_0[5].XM7.G0 vdd 2.56144f
C998 x1.x1[7].XM7.D0 x1.x1[7].XM2.D0 0.04746f
C999 x1.level_shift_0[0].XM2.D0 vdd 1.35464f
C1000 x1.XQ2_7.E a_n2798_n15123# 0.02248f
C1001 x1.x1[3].out x1.level_shift_0[3].in_n 0.02097f
C1002 x2.XMB4.S0 x2.vbn2 1.86852f
C1003 x1.level_shift_0[4].XM2.D0 x1.level_shift_0[3].XM7.D0 0.04779f
C1004 x1.x1[0].XM2.D0 vdd 1.21181f
C1005 x1.level_shift_0[2].in_n x1.x1[3].XM2.D0 0.01864f
C1006 x1.vs2 a_2009_n22299# 0.01858f
C1007 x2.diffb vdd 7.74355f
C1008 x1.level_shift_0[2].XM2.D0 x1.x1[3].out 0.01451f
C1009 x1.level_shift_0[4].out x1.level_shift_0[5].XM7.D0 0.08653f
C1010 x1.level_shift_0[0].out x1.level_shift_0[1].XM2.D0 0.07545f
C1011 x1.level_shift_0[2].XM7.D0 x1.x1[3].out 0.21718f
C1012 x1.vs2 a_3287_n22299# 0.28745f
C1013 x1.XM1.G0 x1.xres.XR1[10].R1 0.05078f
C1014 x1.xres.XR1[11].R2 x1.xres.XR1[12].R2 0.19948f
C1015 x1.x1[1].XM7.G0 trim[14] 0.15949f
C1016 x1.xtr.top a_2861_n22299# 0.01322f
C1017 x1.level_shift_0[6].XM2.D0 trim[2] 1.35191f
C1018 x1.level_shift_0[7].XM2.D0 vdd 1.28659f
C1019 x1.x1[1].out trim[8] 0.01301f
C1020 x1.x1[4].XM7.G0 x1.x1[3].out 0.01858f
C1021 a_2222_n22299# x1.ena_b_h 0.01937f
C1022 x1.xtr.XM0[6].S x1.xtr.XM0[7].S 0.14646f
C1023 x1.xamp.vbp2 x1.xamp.XM8.D0 6.50877f
C1024 x1.level_shift_0[0].XM7.D0 x1.level_shift_0[0].XM2.D0 0.05094f
C1025 x2.outa1p vbg 2.63952f
C1026 x1.vs2 x1.xres.XR1[15].R2 0.01893f
C1027 x2.outb1n x2.outa1p 0.18936f
C1028 x1.x1[3].in_n trim[11] 0.55345f
C1029 x1.xtr.XM0[10].S a_n2798_n17331# 0.19209f
C1030 x1.x1[6].XM2.D0 vdd 1.28662f
C1031 a_2648_n22299# x1.xres.c 0.03693f
C1032 trim[15] ena 0.05112f
C1033 x1.x1[8].XM7.G0 x1.x1[7].out 0.0192f
C1034 x1.vs2 a_n760_n22299# 0.01249f
C1035 x1.x1[7].XM2.D0 trim[3] 1.37055f
C1036 x1.xamp.vbn1 ibias1_250n 0.01417f
C1037 x1.level_shift_0[4].XM7.D0 vdd 2.70116f
C1038 x1.level_shift_0[1].out trim[10] 0.0533f
C1039 x1.xamp.vbn1 x1.xamp.out1p 7.00661f
C1040 x1.xtr.XM0[11].S x1.level_shift_0[2].out 0.13846f
C1041 x1.level_shift_0[4].XM2.D0 x1.x1[4].out 0.02009f
C1042 x1.level_shift_0[5].XM7.D0 trim[4] 0.21012f
C1043 x2.vbn1 x2.vbn2 1.20707f
C1044 x1.xamp.vbp1 vdd 24.4089f
C1045 trim[3] trim[4] 0.04045f
C1046 x1.xres.c x1.xamp.XM1.S0 5.95734f
C1047 x1.x1[4].out x1.XQ2_7.E 0.40738f
C1048 x1.xamp.vbn1 x1.xamp.out1n 4.24973f
C1049 x2.diffa x2.outa1n 3.61556f
C1050 x1.x1[8].XM2.D0 vdd 1.28662f
C1051 x1.level_shift_0[3].XM2.D0 x1.x1[2].out 0.01104f
C1052 x1.xamp.vbp2 vdd 31.3063f
C1053 x1.xamp.vbn1 x1.xamp.vbn2 7.16335f
C1054 x1.x1[7].XM2.D0 x1.x1[6].XM7.D0 0.04515f
C1055 x1.level_shift_0[4].out x1.x1[6].out 0.37583f
C1056 x1.level_shift_0[5].XM7.G0 x1.level_shift_0[5].XM7.D0 2.21752f
C1057 a_n121_n22299# a_92_n22299# 0.74283f
C1058 x1.level_shift_0[3].XM7.G0 trim[8] 0.09307f
C1059 x1.xres.XR1[3].R2 a_n547_n22299# 0.06253f
C1060 x1.xtr.top a_1583_n22299# 0.01326f
C1061 x1.x1[5].XM7.D0 vdd 2.70469f
C1062 x1.XM1.S0 a_n1186_n22299# 0.02466f
C1063 x1.x1[4].in_n x1.x1[4].XM2.D0 0.20674f
C1064 x1.level_shift_0[4].in_n x1.level_shift_0[1].out 0.04297f
C1065 x1.vbg a_n1186_n22299# 0.01128f
C1066 x1.x1[1].out x1.x1[1].XM7.G0 0.0304f
C1067 x1.x1[6].XM7.D0 trim[4] 0.27036f
C1068 x2.outb1p x2.vbn2 12.2551f
C1069 x1.xamp.out1p x1.xamp.out1n 36.8908f
C1070 a_n2798_n18067# a_n2798_n18435# 0.1176f
C1071 x1.level_shift_0[4].XM2.D0 x1.level_shift_0[2].out 0.01087f
C1072 x1.level_shift_0[7].XM2.D0 x1.x1[7].out 0.01869f
C1073 x1.xtr.XM0[15].S a_n2798_n19171# 0.19209f
C1074 x1.x1[8].XM2.D0 x1.x1[7].XM7.D0 0.04515f
C1075 x1.xamp.vbn2 ibias1_250n 0.48693f
C1076 x1.level_shift_0[2].XM7.G0 x1.level_shift_0[2].out 0.01033f
C1077 x1.XQ2_7.E x1.level_shift_0[2].out 0.40791f
C1078 x1.xamp.out1p x1.xamp.vbn2 6.45914f
C1079 x1.level_shift_0[3].XM7.D0 x1.level_shift_0[3].XM7.G0 2.21752f
C1080 a_1370_n22299# a_1583_n22299# 0.74283f
C1081 x1.xamp.vbn1 x1.ena_b_h 0.1908f
C1082 x1.x1[1].in_n x1.x1[1].XM7.G0 1.46694f
C1083 x1.xtr.XM0[12].S a_n2798_n18067# 0.19209f
C1084 x1.level_shift_0[3].XM2.D0 x1.x1[3].out 0.02017f
C1085 x1.xres.XR1[6].R1 a_92_n22299# 0.0564f
C1086 x1.xamp.out1n x1.xamp.vbn2 4.55104f
C1087 x1.level_shift_0[6].XM2.D0 vdd 1.28659f
C1088 x1.xtr.top x1.xres.XR1[14].R1 0.02816f
C1089 x1.x1[5].XM7.G0 x1.level_shift_0[4].in_n 0.20052f
C1090 trim[15] trim[14] 0.02325f
C1091 x1.x1[7].XM2.D0 x1.x1[6].out 0.03316f
C1092 x1.x1[7].in_n x1.x1[7].XM2.D0 0.20386f
C1093 x1.vs2 a_305_n22299# 0.01277f
C1094 x1.level_shift_0[3].out trim[6] 0.09599f
C1095 x1.x1[5].out vdd 0.92873f
C1096 x1.x1[1].XM2.D0 vdd 1.30283f
C1097 x2.vbn2 x2.vbp1 2.12889f
C1098 x2.outb1p x2.diffb 7.14101f
C1099 x1.vs1 vdd 0.42622f
C1100 x1.ena_b_h ibias1_250n 2.14506f
C1101 x1.xtr.XM0[13].S x1.level_shift_0[1].out 0.13929f
C1102 x1.ena_b_h x1.xamp.out1p 0.21613f
C1103 x1.xtr.top a_n1186_n22299# 0.04248f
C1104 x2.outb1n vbg 6.26314f
C1105 x2.XM9.D0_0 x2.outa1n 8.04575f
C1106 x1.x1[0].XM7.D0 x1.ena_b_h 2.74683f
C1107 x1.x1[6].out trim[4] 0.14759f
C1108 x1.level_shift_0[6].XM7.G0 x1.level_shift_0[6].XM2.D0 2.18793f
C1109 x1.x1[4].in_n trim[9] 0.60563f
C1110 x1.ena_b_h x1.xamp.out1n 0.19016f
C1111 x1.xtr.XM0[9].S x1.xtr.XM0[10].S 0.14646f
C1112 x1.x1[3].XM7.D0 vdd 2.70481f
C1113 x1.xres.XR1[9].R1 a_518_n22299# 0.02471f
C1114 x1.level_shift_0[5].XM7.G0 x1.x1[6].out 0.02163f
C1115 x1.xres.XR1[18].R1 a_2861_n22299# 0.05172f
C1116 x1.x1[8].XM2.D0 x1.x1[7].out 0.0334f
C1117 x1.x1[2].out vdd 0.91844f
C1118 x1.ena_b_h x1.xamp.vbn2 1.24258f
C1119 x2.XMOP.G0_0 x2.outa1n 26.8273f
C1120 x1.ena_b_h vbg 1.06766f
C1121 x1.x1[3].XM7.G0 trim[10] 0.16927f
C1122 x1.vbg x1.xamp.XM1.S0 0.03337f
C1123 x1.vs2 x1.xres.XR1[7].R2 0.01656f
C1124 x1.level_shift_0[4].XM7.D0 x1.level_shift_0[5].XM7.D0 0.0167f
C1125 x1.ena_b_h x2.outb1n 0.01385f
C1126 x1.level_shift_0[0].out x1.level_shift_0[3].in_n 0.01076f
C1127 x1.level_shift_0[5].out trim[2] 0.10463f
C1128 x1.xtr.top x1.xres.XR1[1].R1 0.06871f
C1129 x2.vbp1 x2.diffb 3.29597f
C1130 x1.x1[6].XM7.D0 x1.x1[6].XM2.D0 0.04746f
C1131 x1.level_shift_0[2].XM7.D0 x1.level_shift_0[3].in_n 0.05008f
C1132 a_n1186_n22299# x1.XQ2_7.E 0.06014f
C1133 x1.level_shift_0[0].out x1.level_shift_0[2].XM2.D0 0.01102f
C1134 x1.xtr.XM0[3].S x1.xtr.XM0[4].S 0.14646f
C1135 x1.xres.XR1[13].R1 x1.xres.XR1[14].R1 0.24692f
C1136 x1.level_shift_0[5].XM2.D0 x1.level_shift_0[3].out 0.01095f
C1137 x1.x1[4].out x1.level_shift_0[3].XM7.G0 0.02653f
C1138 x1.level_shift_0[0].out x1.level_shift_0[2].XM7.D0 0.02633f
C1139 x1.level_shift_0[4].out x1.XQ2_7.E 0.40722f
C1140 x1.level_shift_0[4].XM7.G0 trim[6] 0.09307f
C1141 trim[9] trim[10] 0.08607f
C1142 x1.level_shift_0[2].XM7.D0 x1.level_shift_0[2].XM2.D0 0.05094f
C1143 x1.xtr.top a_2648_n22299# 0.01334f
C1144 x1.XQ2_7.E x1.xtr.XM0[8].S 0.30301f
C1145 x1.level_shift_0[1].XM7.D0 trim[10] 0.03336f
C1146 x1.x1[4].XM7.G0 x1.level_shift_0[3].in_n 0.20038f
C1147 x1.xres.XR1[4].R2 x1.xres.XR1[7].R2 0.02835f
C1148 x1.x1[2].XM2.D0 trim[13] 1.37965f
C1149 x1.x1[0].XM2.D0 ena 0.19019f
C1150 x2.vbn2 ibias2_1u 0.01198f
C1151 x1.vbg x2.diffb 4.2142f
C1152 x1.XM1.G0 a_2009_n22299# 0.02162f
C1153 x1.x1[3].out vdd 0.9236f
C1154 x1.x1[5].XM2.D0 trim[7] 1.37913f
C1155 x1.x1[7].out x1.level_shift_0[6].XM2.D0 0.01016f
C1156 x1.XQ2_7.E x1.xtr.XM0[2].S 0.31038f
C1157 x1.level_shift_0[1].XM2.D0 vdd 1.28674f
C1158 x1.level_shift_0[2].XM7.G0 trim[10] 0.09307f
C1159 x1.x1[2].XM2.D0 vdd 1.28662f
C1160 x1.xtr.top a_n121_n22299# 0.01613f
C1161 x1.XM1.G0 a_3287_n22299# 0.0338f
C1162 x1.x1[1].in_n trim[15] 0.57596f
C1163 x1.xtr.XM0[7].S a_n2798_n16227# 0.19209f
C1164 x1.vs2 a_2861_n22299# 0.09888f
C1165 a_n1399_n22299# a_n1186_n22299# 0.74283f
C1166 x1.level_shift_0[3].XM7.G0 x1.level_shift_0[2].out 0.03827f
C1167 x1.x1[8].XM7.G0 x1.level_shift_0[7].in_n 0.20052f
C1168 x1.level_shift_0[6].XM2.D0 x1.level_shift_0[5].XM7.D0 0.04779f
C1169 trim[7] trim[6] 0.02315f
C1170 x1.xtr.XM0[4].S a_n2798_n15123# 0.19209f
C1171 x1.x1[5].in_n vdd 0.05434f
C1172 x1.vs2 x1.xres.XR1[12].R2 0.02962f
C1173 x1.x1[6].in_n trim[4] 0.1242f
C1174 x1.level_shift_0[4].XM2.D0 x1.level_shift_0[4].in_n 0.13434f
C1175 x2.diffb ibias2_1u 0.59916f
C1176 x1.x1[5].out x1.level_shift_0[5].XM7.D0 0.1125f
C1177 x1.xtr.XM0[1].S a_n2798_n14019# 0.19209f
C1178 x1.xtr.top x1.xres.XR1[6].R1 0.02851f
C1179 x1.xtr.XM0[15].S x1.xtr.XM0[14].S 0.14646f
C1180 x1.XQ2_7.E a_n2798_n14755# 0.02522f
C1181 x1.x1[5].XM7.G0 x1.x1[5].XM7.D0 2.21217f
C1182 x1.level_shift_0[1].XM2.D0 x1.level_shift_0[0].XM7.D0 0.04779f
C1183 x1.XM1.G0 a_n760_n22299# 0.04061f
C1184 x1.level_shift_0[0].XM2.D0 trim[14] 1.35191f
C1185 a_944_n22299# a_1157_n22299# 0.74283f
C1186 x2.outa1p vdd 7.31356f
C1187 x1.x1[1].out x1.x1[2].XM7.G0 0.01693f
C1188 x1.x1[1].out trim[10] 0.01279f
C1189 x1.x1[2].XM7.G0 trim[12] 0.15579f
C1190 x1.xres.d x1.xamp.out1p 0.60408f
C1191 x1.level_shift_0[5].out vdd 0.59332f
C1192 x1.level_shift_0[1].XM7.G0 x1.x1[2].out 0.04885f
C1193 x1.level_shift_0[0].out x1.level_shift_0[0].XM7.G0 0.01595f
C1194 x1.x1[0].XM7.G0 trim[15] 0.03221f
C1195 x1.level_shift_0[7].XM2.D0 x1.level_shift_0[7].in_n 0.13434f
C1196 x1.level_shift_0[0].XM7.G0 x1.ena_b_h 0.05956f
C1197 x1.x1[8].XM7.G0 x1.x1[8].in_n 1.46694f
C1198 a_n2798_n15123# a_n2798_n15491# 0.1176f
C1199 x1.xres.d x1.xamp.out1n 4.82054f
C1200 trim[1] trim[2] 0.0876f
C1201 x1.vs2 a_1583_n22299# 0.01392f
C1202 dvdd vss 0.18023f
C1203 dvss vss 0.21106f
C1204 vbg vss 0.16309p
C1205 ibias2_1u vss 10.95854f
C1206 ibias1_250n vss 0.41219f
C1207 vdd vss 0.33502p
C1208 x2.diffa vss 70.55243f
C1209 x2.outb1n vss 32.05591f
C1210 x2.outb1p vss 32.84966f
C1211 x2.outa1p vss 26.54287f
C1212 x2.outa1n vss 24.10588f
C1213 x2.diffb vss 32.74898f
C1214 x1.xamp.XM1.S0 vss 6.44085f
C1215 x1.xamp.XM8.D0 vss 0.94874f
C1216 x1.xamp.XM8.S1 vss 0.03155f
C1217 x1.level_shift_0[0].XM2.D0 vss 0.34621f
C1218 x1.xamp.out1n vss 13.75139f
C1219 x1.xamp.out1p vss 25.31506f
C1220 x1.xres.XR1[18].R1 vss 2.10402f
C1221 x1.xres.XR1[17].R1 vss 2.13755f
C1222 x1.xres.XR1[16].R2 vss 2.32277f
C1223 x1.xres.XR1[15].R2 vss 2.13473f
C1224 x1.xres.XR1[14].R1 vss 2.0993f
C1225 x1.xres.XR1[13].R1 vss 2.13722f
C1226 x1.xres.XR1[12].R2 vss 2.3483f
C1227 x1.xres.XR1[11].R2 vss 2.14511f
C1228 x1.xres.XR1[10].R1 vss 2.11098f
C1229 x1.xres.XR1[9].R1 vss 2.14774f
C1230 x1.xres.XR1[8].R2 vss 2.3764f
C1231 x1.xres.XR1[7].R2 vss 2.15696f
C1232 x1.xres.XR1[6].R1 vss 2.11224f
C1233 x1.xres.XR1[5].R1 vss 2.15068f
C1234 x1.xres.XR1[4].R2 vss 2.38074f
C1235 x1.xres.XR1[3].R2 vss 2.17186f
C1236 x1.xres.XR1[2].R1 vss 2.12767f
C1237 x1.xres.XR1[1].R1 vss 2.20534f
C1238 x1.XM1.S0 vss 0.82677p
C1239 x1.x1[1].out vss 0.33193f
C1240 x1.xtr.top vss 6.01922f
C1241 x1.level_shift_0[0].out vss 1.08124f
C1242 x1.xtr.XM0[15].S vss 2.15224f
C1243 x1.x1[2].out vss 0.32989f
C1244 x1.xtr.XM0[14].S vss 2.56574f
C1245 x1.level_shift_0[1].out vss 0.79766f
C1246 x1.xtr.XM0[13].S vss 2.15975f
C1247 x1.xtr.XM0[12].S vss 2.15424f
C1248 x1.level_shift_0[2].out vss 0.44855f
C1249 x1.xtr.XM0[11].S vss 2.21354f
C1250 x1.xtr.XM0[10].S vss 2.48029f
C1251 x1.xtr.XM0[9].S vss 2.18625f
C1252 x1.xtr.XM0[8].S vss 2.61998f
C1253 x1.xtr.XM0[7].S vss 2.73362f
C1254 x1.xtr.XM0[6].S vss 2.54191f
C1255 x1.xtr.XM0[5].S vss 2.35605f
C1256 x1.xtr.XM0[4].S vss 2.27702f
C1257 x1.xtr.XM0[3].S vss 2.47194f
C1258 x1.xtr.XM0[2].S vss 2.91518f
C1259 x1.xtr.XM0[1].S vss 2.79629f
C1260 x1.XQ2_7.E vss 39.95841f
C1261 x1.x1[3].out vss 0.56357f
C1262 x1.level_shift_0[3].XM2.D0 vss 1.81889f
C1263 x1.level_shift_0[3].out vss 0.30553f
C1264 x1.x1[4].XM2.D0 vss 0.57223f
C1265 x1.level_shift_0[4].XM2.D0 vss 0.35153f
C1266 x1.x1[5].out vss 0.08175f
C1267 x1.level_shift_0[5].XM7.G0 vss 0.70801f
C1268 x1.x1[6].XM2.D0 vss 0.94649f
C1269 x1.level_shift_0[6].XM2.D0 vss 1.65218f
C1270 x1.x1[7].XM7.G0 vss 0.97118f
C1271 x1.level_shift_0[7].out vss 0.66565f
C1272 x1.x1[8].out vss 0.32504f
C1273 x2.outa1n.n0 vss 0.89372f
C1274 x2.outa1n.n1 vss 3.20964f
C1275 x2.outa1n.n2 vss 3.92499f
C1276 x2.outa1n.n3 vss 0.44736f
C1277 x2.outa1n.n4 vss 0.82616f
C1278 x2.outa1n.n5 vss 0.81728f
C1279 x2.outa1n.n6 vss 1.55569f
C1280 x2.outa1n.n7 vss 0.85698f
C1281 x2.outa1n.n8 vss 1.71396f
C1282 x2.outa1n.n9 vss 1.55569f
C1283 x2.outa1n.n10 vss 1.68263f
C1284 x2.outa1n.n11 vss 0.47392f
C1285 x2.outa1n.n12 vss 0.72926f
C1286 x2.outa1n.n13 vss 0.46784f
C1287 x2.outa1n.n14 vss 0.92487f
C1288 x2.outa1n.n15 vss 0.69116f
C1289 x2.outa1n.n16 vss 0.77702f
C1290 x2.outa1n.n17 vss 0.52683f
C1291 x2.outa1n.n18 vss 0.78449f
C1292 x2.outa1n.n19 vss 0.69317f
C1293 x2.outa1n.n20 vss 0.69806f
C1294 x2.outa1n.n21 vss 0.69273f
C1295 x2.outa1n.n22 vss 0.66964f
C1296 x2.outa1n.n23 vss 0.44822f
C1297 x2.outa1n.n24 vss 0.45588f
C1298 x2.outa1n.n25 vss 0.73613f
C1299 x2.outa1n.n26 vss 0.43361f
C1300 x2.outa1n.n27 vss 0.78922f
C1301 x2.outa1n.n28 vss 0.74497f
C1302 x2.outa1n.n29 vss 1.53702f
C1303 x2.outa1n.n30 vss 3.29604f
C1304 x2.outa1n.n31 vss 0.98296f
C1305 x2.outa1n.n32 vss 1.99817f
C1306 x2.outa1n.n33 vss 2.94426f
C1307 x2.outa1n.n34 vss 0.9822f
C1308 x2.outa1n.n35 vss 0.73405f
C1309 x2.outa1n.n36 vss 0.73663f
C1310 x2.outa1n.n37 vss 0.22028f
C1311 x2.outa1n.n38 vss 0.71302f
C1312 x2.outa1n.n39 vss 0.74095f
C1313 x2.outa1n.n40 vss 0.88126f
C1314 x2.outa1n.n41 vss 0.74436f
C1315 x2.outa1n.n42 vss 1.53191f
C1316 x2.outa1n.n43 vss 0.60676f
C1317 x2.outa1n.n44 vss 0.8454f
C1318 x2.outa1n.n45 vss 2.06729f
C1319 x2.outa1n.n46 vss 0.01707f
C1320 x2.outa1n.t1 vss 0.54823f
C1321 x2.outa1n.n47 vss 0.29096f
C1322 x2.outa1n.t3 vss 0.54823f
C1323 x2.outa1n.n48 vss 0.20492f
C1324 x2.outa1n.t25 vss 0.14976f
C1325 x2.outa1n.n49 vss 0.02528f
C1326 x2.outa1n.t29 vss 0.14976f
C1327 x2.outa1n.t32 vss 0.14976f
C1328 x2.outa1n.t35 vss 0.14976f
C1329 x2.outa1n.t39 vss 0.14976f
C1330 x2.outa1n.n50 vss 0.02103f
C1331 x2.outa1n.n51 vss 0.01935f
C1332 x2.outa1n.t17 vss 0.54823f
C1333 x2.outa1n.n52 vss 0.31146f
C1334 x2.outa1n.t23 vss 0.54823f
C1335 x2.outa1n.n53 vss 0.0341f
C1336 x2.outa1n.n54 vss 0.59908f
C1337 x2.outa1n.n55 vss 0.02641f
C1338 x2.outa1n.t21 vss 0.54823f
C1339 x2.outa1n.n56 vss 0.0341f
C1340 x2.outa1n.n57 vss 0.59649f
C1341 x2.outa1n.n58 vss 0.29219f
C1342 x2.outa1n.t19 vss 0.54823f
C1343 x2.outa1n.n59 vss 0.29219f
C1344 x2.outa1n.t5 vss 0.54823f
C1345 x2.outa1n.n60 vss 0.03298f
C1346 x2.outa1n.n61 vss 0.59294f
C1347 x2.outa1n.t7 vss 0.54823f
C1348 x2.outa1n.n62 vss 0.03298f
C1349 x2.outa1n.n63 vss 0.59035f
C1350 x2.outa1n.n64 vss 0.05909f
C1351 x2.outa1n.t9 vss 0.54823f
C1352 x2.outa1n.n65 vss 0.03298f
C1353 x2.outa1n.n66 vss 0.59078f
C1354 x2.outa1n.n67 vss 0.29096f
C1355 x2.outa1n.t11 vss 0.54823f
C1356 x2.outa1n.n68 vss 0.02742f
C1357 x2.outa1n.t30 vss 0.14976f
C1358 x2.outa1n.n69 vss 0.48315f
C1359 x2.outa1n.t26 vss 0.14976f
C1360 x2.outa1n.n70 vss 0.43622f
C1361 x2.outa1n.n71 vss 0.29096f
C1362 x2.outa1n.t13 vss 0.54823f
C1363 x2.outa1n.n72 vss 0.0341f
C1364 x2.outa1n.n73 vss 0.59822f
C1365 x2.outa1n.n74 vss 0.02427f
C1366 x2.outa1n.t15 vss 0.54823f
C1367 x2.outa1n.n75 vss 0.0341f
C1368 x2.outa1n.n76 vss 0.59778f
C1369 x2.outa1n.n77 vss 0.29219f
C1370 x2.outa1n.t27 vss 0.14976f
C1371 x2.outa1n.n78 vss 0.73718f
C1372 x2.outa1n.n79 vss 0.21803f
C1373 x2.outa1n.t31 vss 0.14976f
C1374 x2.outa1n.n80 vss 0.73686f
C1375 x2.outa1n.n81 vss 0.62045f
C1376 x2.outa1n.t38 vss 0.14976f
C1377 x2.outa1n.n82 vss 0.43728f
C1378 x2.outa1n.t34 vss 0.14976f
C1379 x2.outa1n.n83 vss 0.45057f
C1380 x2.outa1n.n84 vss 0.47802f
C1381 x2.outa1n.n85 vss 0.48162f
C1382 x2.outa1n.t37 vss 0.14976f
C1383 x2.outa1n.n86 vss 0.43527f
C1384 x2.outa1n.t36 vss 0.14976f
C1385 x2.outa1n.n87 vss 0.88326f
C1386 x2.outa1n.n88 vss 0.75454f
C1387 x2.outa1n.t33 vss 0.823f
C1388 x2.outa1n.n89 vss 0.43421f
C1389 x2.outa1n.t28 vss 0.14976f
C1390 x2.outa1n.n90 vss 0.85099f
C1391 x2.outa1n.n91 vss 0.43682f
C1392 x2.outa1n.t24 vss 0.14976f
C1393 x2.outa1n.n92 vss 0.75704f
C1394 x2.outa1n.n93 vss 0.29096f
C1395 x2.outa1n.t40 vss 1.89957f
C1396 x2.outa1n.t41 vss 1.89957f
C1397 x2.outa1n.t42 vss 1.90071f
C1398 x2.outa1n.t43 vss 1.97583f
C1399 x2.outa1n.t44 vss 1.89595f
C1400 x2.outa1n.t45 vss 1.89595f
C1401 x2.outa1n.t46 vss 1.89473f
C1402 x2.outa1n.t47 vss 1.99334f
C1403 x2.outa1p.n0 vss 3.83591f
C1404 x2.outa1p.n1 vss 3.94073f
C1405 x2.outa1p.n2 vss 2.34836f
C1406 x2.outa1p.n3 vss 0.71309f
C1407 x2.outa1p.n4 vss 2.58762f
C1408 x2.outa1p.n5 vss 3.25641f
C1409 x2.outa1p.n6 vss 0.7432f
C1410 x2.outa1p.n7 vss 2.16332f
C1411 x2.outa1p.n8 vss 1.33429f
C1412 x2.outa1p.n9 vss 0.87503f
C1413 x2.outa1p.n10 vss 1.33901f
C1414 x2.outa1p.n11 vss 0.95958f
C1415 x2.outa1p.n12 vss 0.75158f
C1416 x2.outa1p.n13 vss 0.95925f
C1417 x2.outa1p.n14 vss 0.51019f
C1418 x2.outa1p.n15 vss 0.97317f
C1419 x2.outa1p.n16 vss 0.97025f
C1420 x2.outa1p.n17 vss 0.87895f
C1421 x2.outa1p.n18 vss 0.53543f
C1422 x2.outa1p.n19 vss 0.97891f
C1423 x2.outa1p.n20 vss 1.97157f
C1424 x2.outa1p.n21 vss 0.97943f
C1425 x2.outa1p.n22 vss 1.01494f
C1426 x2.outa1p.n23 vss 0.82918f
C1427 x2.outa1p.n24 vss 0.55059f
C1428 x2.outa1p.n25 vss 0.69786f
C1429 x2.outa1p.n26 vss 0.74695f
C1430 x2.outa1p.n27 vss 0.74756f
C1431 x2.outa1p.n28 vss 0.59899f
C1432 x2.outa1p.n29 vss 0.68309f
C1433 x2.outa1p.n30 vss 0.72732f
C1434 x2.outa1p.n31 vss 0.76028f
C1435 x2.outa1p.n32 vss 0.70944f
C1436 x2.outa1p.n33 vss 1.0506f
C1437 x2.outa1p.n34 vss 0.99663f
C1438 x2.outa1p.n35 vss 2.47384f
C1439 x2.outa1p.n36 vss 3.66992f
C1440 x2.outa1p.n37 vss 1.93173f
C1441 x2.outa1p.n38 vss 4.12596f
C1442 x2.outa1p.n39 vss 0.93233f
C1443 x2.outa1p.n40 vss 0.90908f
C1444 x2.outa1p.n41 vss 0.91789f
C1445 x2.outa1p.n42 vss 0.90488f
C1446 x2.outa1p.t11 vss 0.58671f
C1447 x2.outa1p.t16 vss 0.18823f
C1448 x2.outa1p.t8 vss 0.58671f
C1449 x2.outa1p.t21 vss 0.18823f
C1450 x2.outa1p.t30 vss 0.18823f
C1451 x2.outa1p.t26 vss 0.18823f
C1452 x2.outa1p.t31 vss 0.18823f
C1453 x2.outa1p.t15 vss 0.58671f
C1454 x2.outa1p.t10 vss 0.58671f
C1455 x2.outa1p.t34 vss 0.58671f
C1456 x2.outa1p.n43 vss 0.46012f
C1457 x2.outa1p.t33 vss 0.58671f
C1458 x2.outa1p.t19 vss 0.18823f
C1459 x2.outa1p.n44 vss 0.92382f
C1460 x2.outa1p.t13 vss 0.58671f
C1461 x2.outa1p.t14 vss 0.58671f
C1462 x2.outa1p.t32 vss 0.58671f
C1463 x2.outa1p.t22 vss 0.18823f
C1464 x2.outa1p.n45 vss 0.57292f
C1465 x2.outa1p.t17 vss 0.18823f
C1466 x2.outa1p.n46 vss 0.5416f
C1467 x2.outa1p.t9 vss 0.58671f
C1468 x2.outa1p.t35 vss 0.58671f
C1469 x2.outa1p.t12 vss 0.58671f
C1470 x2.outa1p.n47 vss 0.56325f
C1471 x2.outa1p.t18 vss 0.18823f
C1472 x2.outa1p.n48 vss 0.54942f
C1473 x2.outa1p.t23 vss 0.18823f
C1474 x2.outa1p.n49 vss 1.03197f
C1475 x2.outa1p.t27 vss 0.18823f
C1476 x2.outa1p.n50 vss 0.92165f
C1477 x2.outa1p.n51 vss 0.55798f
C1478 x2.outa1p.n52 vss 0.56172f
C1479 x2.outa1p.t25 vss 0.18823f
C1480 x2.outa1p.n53 vss 0.576f
C1481 x2.outa1p.t29 vss 0.18823f
C1482 x2.outa1p.n54 vss 0.42358f
C1483 x2.outa1p.t28 vss 0.18823f
C1484 x2.outa1p.n55 vss 0.97726f
C1485 x2.outa1p.t24 vss 0.18823f
C1486 x2.outa1p.n56 vss 0.5161f
C1487 x2.outa1p.t20 vss 0.18823f
C1488 x2.outa1p.n57 vss 0.98512f
C1489 x2.outa1p.t0 vss 53.91345f
C1490 x2.outa1p.t1 vss 0.37647f
C1491 x2.outa1p.t2 vss 0.37647f
C1492 x2.outa1p.t3 vss 0.37647f
C1493 x2.outa1p.t4 vss 0.37647f
C1494 x2.outa1p.t5 vss 0.37647f
C1495 x2.outa1p.t6 vss 0.37647f
C1496 x2.outa1p.t7 vss 0.37647f
C1497 x2.outb1p.n0 vss 1.5454f
C1498 x2.outb1p.n1 vss 2.46345f
C1499 x2.outb1p.n2 vss 0.32124f
C1500 x2.outb1p.n3 vss 0.45661f
C1501 x2.outb1p.n4 vss 2.16251f
C1502 x2.outb1p.n5 vss 0.31682f
C1503 x2.outb1p.n6 vss 0.43441f
C1504 x2.outb1p.n7 vss 2.35866f
C1505 x2.outb1p.n8 vss 1.91318f
C1506 x2.outb1p.n9 vss 0.2852f
C1507 x2.outb1p.n10 vss 1.84249f
C1508 x2.outb1p.n11 vss 0.31007f
C1509 x2.outb1p.n12 vss 0.44807f
C1510 x2.outb1p.n13 vss 3.30204f
C1511 x2.outb1p.n14 vss 1.11847f
C1512 x2.outb1p.n15 vss 1.11243f
C1513 x2.outb1p.n16 vss 1.11438f
C1514 x2.outb1p.n17 vss 2.50168f
C1515 x2.outb1p.n18 vss 3.01356f
C1516 x2.outb1p.n19 vss 1.14274f
C1517 x2.outb1p.n20 vss 1.14468f
C1518 x2.outb1p.n21 vss 0.2852f
C1519 x2.outb1p.n22 vss 0.64886f
C1520 x2.outb1p.n23 vss 1.10878f
C1521 x2.outb1p.n24 vss 0.2852f
C1522 x2.outb1p.n25 vss 0.64283f
C1523 x2.outb1p.n26 vss 1.11074f
C1524 x2.outb1p.n27 vss 1.11052f
C1525 x2.outb1p.n28 vss 1.10448f
C1526 x2.outb1p.n29 vss 1.10669f
C1527 x2.outb1p.n30 vss 1.66758f
C1528 x2.outb1p.n31 vss 0.31778f
C1529 x2.outb1p.n32 vss 0.2852f
C1530 x2.outb1p.n33 vss 1.59808f
C1531 x2.outb1p.t3 vss 0.58635f
C1532 x2.outb1p.t2 vss 0.58635f
C1533 x2.outb1p.t1 vss 0.58635f
C1534 x2.outb1p.t0 vss 0.58635f
C1535 x2.outb1p.n34 vss 2.26603f
C1536 x2.outb1p.t38 vss 0.14659f
C1537 x2.outb1p.t26 vss 0.14659f
C1538 x2.outb1p.n35 vss 0.44821f
C1539 x2.outb1p.t20 vss 0.29317f
C1540 x2.outb1p.t41 vss 0.14659f
C1541 x2.outb1p.t29 vss 0.14659f
C1542 x2.outb1p.n36 vss 0.44967f
C1543 x2.outb1p.n37 vss 0.2852f
C1544 x2.outb1p.t21 vss 0.29317f
C1545 x2.outb1p.t43 vss 0.14659f
C1546 x2.outb1p.t31 vss 0.14659f
C1547 x2.outb1p.n38 vss 0.44821f
C1548 x2.outb1p.n39 vss 0.2852f
C1549 x2.outb1p.t22 vss 0.29317f
C1550 x2.outb1p.t44 vss 0.14659f
C1551 x2.outb1p.t32 vss 0.14659f
C1552 x2.outb1p.t46 vss 0.14659f
C1553 x2.outb1p.t34 vss 0.14659f
C1554 x2.outb1p.n40 vss 0.44821f
C1555 x2.outb1p.t23 vss 0.29317f
C1556 x2.outb1p.t11 vss 0.29317f
C1557 x2.outb1p.t15 vss 0.29317f
C1558 x2.outb1p.t14 vss 0.29317f
C1559 x2.outb1p.t10 vss 0.29317f
C1560 x2.outb1p.t13 vss 0.29317f
C1561 x2.outb1p.t9 vss 0.29317f
C1562 x2.outb1p.t12 vss 0.29317f
C1563 x2.outb1p.t8 vss 0.29317f
C1564 x2.outb1p.n41 vss 0.65983f
C1565 x2.outb1p.n42 vss 1.29083f
C1566 x2.outb1p.n43 vss 0.55142f
C1567 x2.outb1p.n44 vss 0.68288f
C1568 x2.outb1p.n45 vss 0.55142f
C1569 x2.outb1p.n46 vss 0.64585f
C1570 x2.outb1p.n47 vss 0.55142f
C1571 x2.outb1p.n48 vss 0.67684f
C1572 x2.outb1p.n49 vss 0.55142f
C1573 x2.outb1p.n50 vss 0.64585f
C1574 x2.outb1p.n51 vss 0.55142f
C1575 x2.outb1p.n52 vss 0.55142f
C1576 x2.outb1p.n53 vss 1.00633f
C1577 x2.outb1p.n54 vss 0.5891f
C1578 x2.outb1p.t16 vss 0.29317f
C1579 x2.outb1p.t17 vss 0.29317f
C1580 x2.outb1p.t18 vss 0.29317f
C1581 x2.outb1p.t19 vss 0.29317f
C1582 x2.outb1p.n55 vss 0.32561f
C1583 x2.outb1p.t47 vss 0.14659f
C1584 x2.outb1p.t35 vss 0.14659f
C1585 x2.outb1p.n56 vss 0.4917f
C1586 x2.outb1p.n57 vss 0.34063f
C1587 x2.outb1p.n58 vss 1.00891f
C1588 x2.outb1p.t45 vss 0.14659f
C1589 x2.outb1p.t33 vss 0.14659f
C1590 x2.outb1p.n59 vss 0.64024f
C1591 x2.outb1p.n60 vss 0.33914f
C1592 x2.outb1p.t42 vss 0.14659f
C1593 x2.outb1p.t30 vss 15.93259f
C1594 x2.outb1p.n61 vss 0.44821f
C1595 x2.outb1p.n62 vss 0.34255f
C1596 x2.outb1p.n63 vss 0.64024f
C1597 x2.outb1p.t40 vss 0.14659f
C1598 x2.outb1p.t28 vss 0.14659f
C1599 x2.outb1p.t39 vss 0.14659f
C1600 x2.outb1p.t27 vss 0.14659f
C1601 x2.outb1p.n64 vss 0.44821f
C1602 x2.outb1p.n65 vss 0.34222f
C1603 x2.outb1p.n66 vss 1.28523f
C1604 x2.outb1p.n67 vss 0.4196f
C1605 x2.outb1p.t37 vss 0.14659f
C1606 x2.outb1p.t25 vss 0.14659f
C1607 x2.outb1p.n68 vss 0.44821f
C1608 x2.outb1p.t36 vss 0.14659f
C1609 x2.outb1p.t24 vss 0.14659f
C1610 x2.outb1p.n69 vss 0.44821f
C1611 x2.outb1p.n70 vss 2.56021f
C1612 x2.outb1p.t6 vss 9.9968f
C1613 x2.outb1p.t5 vss 0.58635f
C1614 x2.outb1p.t4 vss 0.58635f
C1615 x2.outb1p.t7 vss 0.58635f
C1616 x2.outb1n.n0 vss 2.54074f
C1617 x2.outb1n.n1 vss 2.45699f
C1618 x2.outb1n.n2 vss 1.39782f
C1619 x2.outb1n.n3 vss 1.57374f
C1620 x2.outb1n.n4 vss 1.87626f
C1621 x2.outb1n.n5 vss 1.87653f
C1622 x2.outb1n.n6 vss 0.27566f
C1623 x2.outb1n.n7 vss 0.38229f
C1624 x2.outb1n.n8 vss 3.21521f
C1625 x2.outb1n.n9 vss 2.42535f
C1626 x2.outb1n.n10 vss 2.95876f
C1627 x2.outb1n.n11 vss 0.27051f
C1628 x2.outb1n.n12 vss 0.3897f
C1629 x2.outb1n.n13 vss 0.67019f
C1630 x2.outb1n.n14 vss 1.04104f
C1631 x2.outb1n.n15 vss 0.59594f
C1632 x2.outb1n.n16 vss 0.67019f
C1633 x2.outb1n.n17 vss 1.04129f
C1634 x2.outb1n.n18 vss 0.59594f
C1635 x2.outb1n.n19 vss 1.08791f
C1636 x2.outb1n.n20 vss 1.08205f
C1637 x2.outb1n.n21 vss 1.22439f
C1638 x2.outb1n.n22 vss 1.04421f
C1639 x2.outb1n.n23 vss 0.27691f
C1640 x2.outb1n.n24 vss 1.03835f
C1641 x2.outb1n.n25 vss 1.47683f
C1642 x2.outb1n.n26 vss 1.47708f
C1643 x2.outb1n.n27 vss 1.03347f
C1644 x2.outb1n.n28 vss 1.09108f
C1645 x2.outb1n.n29 vss 0.71221f
C1646 x2.outb1n.n30 vss 1.07451f
C1647 x2.outb1n.n31 vss 1.03333f
C1648 x2.outb1n.n32 vss 0.27691f
C1649 x2.outb1n.n33 vss 0.67396f
C1650 x2.outb1n.n34 vss 1.03124f
C1651 x2.outb1n.t19 vss 3.25217f
C1652 x2.outb1n.t18 vss 3.16765f
C1653 x2.outb1n.t17 vss 3.16751f
C1654 x2.outb1n.t16 vss 3.16751f
C1655 x2.outb1n.t37 vss 0.14233f
C1656 x2.outb1n.t25 vss 19.20053f
C1657 x2.outb1n.n35 vss 0.3859f
C1658 x2.outb1n.n36 vss 0.34309f
C1659 x2.outb1n.n37 vss 0.27691f
C1660 x2.outb1n.t38 vss 0.14233f
C1661 x2.outb1n.t26 vss 0.14233f
C1662 x2.outb1n.t40 vss 0.14233f
C1663 x2.outb1n.t28 vss 0.14233f
C1664 x2.outb1n.n38 vss 0.3859f
C1665 x2.outb1n.t9 vss 0.28465f
C1666 x2.outb1n.t14 vss 0.28465f
C1667 x2.outb1n.t42 vss 0.14233f
C1668 x2.outb1n.t30 vss 0.14233f
C1669 x2.outb1n.t44 vss 0.14233f
C1670 x2.outb1n.t32 vss 0.14233f
C1671 x2.outb1n.n39 vss 0.3859f
C1672 x2.outb1n.n40 vss 0.27691f
C1673 x2.outb1n.t15 vss 0.28465f
C1674 x2.outb1n.t47 vss 0.14233f
C1675 x2.outb1n.t35 vss 0.14233f
C1676 x2.outb1n.n41 vss 0.43942f
C1677 x2.outb1n.t46 vss 0.14233f
C1678 x2.outb1n.t34 vss 0.14233f
C1679 x2.outb1n.n42 vss 0.3859f
C1680 x2.outb1n.t3 vss 0.28465f
C1681 x2.outb1n.t1 vss 0.28465f
C1682 x2.outb1n.t6 vss 0.28465f
C1683 x2.outb1n.t4 vss 0.28465f
C1684 x2.outb1n.n43 vss 0.70509f
C1685 x2.outb1n.t0 vss 0.28465f
C1686 x2.outb1n.n44 vss 0.69278f
C1687 x2.outb1n.n45 vss 1.30621f
C1688 x2.outb1n.n46 vss 0.59594f
C1689 x2.outb1n.t5 vss 0.28465f
C1690 x2.outb1n.n47 vss 0.67187f
C1691 x2.outb1n.n48 vss 0.59594f
C1692 x2.outb1n.n49 vss 0.59594f
C1693 x2.outb1n.t2 vss 0.28465f
C1694 x2.outb1n.n50 vss 0.59594f
C1695 x2.outb1n.t7 vss 0.28465f
C1696 x2.outb1n.n51 vss 0.62737f
C1697 x2.outb1n.t11 vss 0.28465f
C1698 x2.outb1n.t10 vss 0.28465f
C1699 x2.outb1n.n52 vss 1.05021f
C1700 x2.outb1n.n53 vss 0.27691f
C1701 x2.outb1n.n54 vss 0.36502f
C1702 x2.outb1n.t45 vss 0.14233f
C1703 x2.outb1n.t33 vss 0.14233f
C1704 x2.outb1n.n55 vss 0.3859f
C1705 x2.outb1n.n56 vss 0.37564f
C1706 x2.outb1n.n57 vss 0.33119f
C1707 x2.outb1n.t43 vss 0.14233f
C1708 x2.outb1n.t31 vss 0.14233f
C1709 x2.outb1n.n58 vss 0.3859f
C1710 x2.outb1n.t41 vss 0.14233f
C1711 x2.outb1n.t29 vss 0.14233f
C1712 x2.outb1n.n59 vss 0.3859f
C1713 x2.outb1n.n60 vss 0.67145f
C1714 x2.outb1n.t13 vss 0.28465f
C1715 x2.outb1n.n61 vss 0.33062f
C1716 x2.outb1n.n62 vss 0.27691f
C1717 x2.outb1n.n63 vss 0.66684f
C1718 x2.outb1n.t8 vss 0.28465f
C1719 x2.outb1n.n64 vss 0.27691f
C1720 x2.outb1n.n65 vss 0.3311f
C1721 x2.outb1n.t39 vss 0.14233f
C1722 x2.outb1n.t27 vss 0.14233f
C1723 x2.outb1n.n66 vss 0.3859f
C1724 x2.outb1n.t12 vss 0.28465f
C1725 x2.outb1n.n67 vss 0.35865f
C1726 x2.outb1n.t36 vss 0.14233f
C1727 x2.outb1n.t24 vss 0.14233f
C1728 x2.outb1n.n68 vss 0.3859f
C1729 x2.outb1n.n69 vss 2.95638f
C1730 x2.outb1n.t22 vss 3.16608f
C1731 x2.outb1n.t21 vss 3.16608f
C1732 x2.outb1n.t20 vss 3.16608f
C1733 x2.outb1n.n70 vss 2.13609f
C1734 x2.outb1n.t23 vss 3.27216f
C1735 vss.t4 vss 1.32433f
C1736 vss.t58 vss 4.80452f
C1737 vss.t177 vss 2.12442f
C1738 vss.t171 vss 1.23972f
C1739 vss.t122 vss 1.22669f
C1740 vss.t271 vss 1.22352f
C1741 vss.t276 vss 1.66235f
C1742 vss.t273 vss 0.55033f
C1743 vss.t5 vss 1.25496f
C1744 vss.t18 vss 7.22685f
C1745 vss.t120 vss 19.0582f
C1746 vss.t242 vss 6.24861f
C1747 vss.t135 vss 5.49591f
C1748 vss.t167 vss 3.44386f
C1749 vss.t125 vss 5.91326f
C1750 vss.t132 vss 2.93373f
C1751 vss.t259 vss 3.98845f
C1752 vss.t31 vss 3.19858f
C1753 vss.t21 vss 0.21208p
C1754 vss.t274 vss 0.55033f
C1755 vss.t14 vss 7.26283f
C1756 vss.t11 vss 5.67542f
C1757 vss.t155 vss 5.73994f
C1758 vss.t7 vss 8.12245f
C1759 vss.t380 vss 1.40197f
C1760 vdd.n0 vss 0.09016f
C1761 vdd.n1 vss 0.09022f
C1762 vdd.n2 vss 0.07602f
C1763 vdd.n3 vss 0.0761f
C1764 vdd.n4 vss 0.0761f
C1765 vdd.n5 vss 0.07602f
C1766 vdd.n6 vss 0.09022f
C1767 vdd.n7 vss 0.09016f
C1768 vdd.n8 vss 0.07602f
C1769 vdd.n9 vss 0.0761f
C1770 vdd.n10 vss 0.09022f
C1771 vdd.n11 vss 0.09016f
C1772 vdd.n12 vss 0.0761f
C1773 vdd.n13 vss 0.07602f
C1774 vdd.n14 vss 0.09022f
C1775 vdd.n15 vss 0.09016f
C1776 vdd.n16 vss 0.09026f
C1777 vdd.n17 vss 0.09022f
C1778 vdd.n18 vss 0.07602f
C1779 vdd.n19 vss 0.0761f
C1780 vdd.n20 vss 0.0761f
C1781 vdd.n21 vss 0.07602f
C1782 vdd.n22 vss 0.09022f
C1783 vdd.n23 vss 0.09016f
C1784 vdd.n24 vss 0.0761f
C1785 vdd.n25 vss 0.07602f
C1786 vdd.n26 vss 0.09022f
C1787 vdd.n27 vss 0.09016f
C1788 vdd.t0 vss 84.32671f
C1789 vdd.t5 vss 0.1708p
C1790 vdd.t6 vss 0.13145p
C1791 vdd.n28 vss 0.09016f
C1792 vdd.n29 vss 0.38622f
C1793 vdd.n30 vss 0.33092f
C1794 vdd.n31 vss 0.38622f
C1795 vdd.n34 vss 0.33465f
C1796 vdd.n35 vss 0.71083f
C1797 vdd.n36 vss 0.09499f
C1798 vdd.n37 vss 0.09499f
C1799 vdd.n38 vss 0.09499f
C1800 vdd.n39 vss 0.09016f
C1801 vdd.n40 vss 0.09022f
C1802 vdd.n41 vss 0.09499f
C1803 vdd.n42 vss 0.07602f
C1804 vdd.n43 vss 0.0761f
C1805 vdd.n44 vss 1.04688f
C1806 vdd.n45 vss 0.09499f
C1807 vdd.n46 vss 0.09492f
C1808 vdd.n47 vss 0.09492f
C1809 vdd.n48 vss 0.09492f
C1810 vdd.n49 vss 2.55478f
C1811 vdd.n50 vss 0.32801f
C1812 vdd.t19 vss 0.34684f
C1813 vdd.n51 vss 0.34607f
C1814 vdd.n52 vss 0.34172f
C1815 vdd.n53 vss 2.19195f
C1816 vdd.t81 vss 27.55901f
C1817 vdd.t83 vss 1.56386f
C1818 vdd.n56 vss 0.3428f
C1819 vdd.t20 vss 0.3239f
C1820 vdd.n57 vss 0.34334f
C1821 vdd.t252 vss 39.39899f
C1822 vdd.n58 vss 1.56532f
C1823 vdd.t99 vss 2.25743f
C1824 vdd.t112 vss 2.14647f
C1825 vdd.t121 vss 1.34678f
C1826 vdd.t105 vss 0.8256p
C1827 vdd.t104 vss 0.1476f
C1828 vdd.t101 vss 9.57211f
C1829 vdd.t103 vss 0.10628p
C1830 vdd.t139 vss 0.0306f
C1831 vdd.t102 vss 0.1476f
C1832 vdd.t140 vss 0.42339p
C1833 vdd.t106 vss 0.03373f
C1834 vdd.t107 vss 1.35947f
C1835 vdd.t199 vss 0.72615f
C1836 vdd.t198 vss 0.92193f
C1837 vdd.t57 vss 0.98723f
C1838 vdd.t58 vss 0.05758f
C1839 vdd.t59 vss 0.07215f
C1840 vdd.t60 vss 1.39327f
C1841 vdd.t151 vss 0.03373f
C1842 vdd.t152 vss 1.49279f
C1843 vdd.n59 vss 0.10584f
C1844 vdd.t132 vss 0.73192f
C1845 vdd.t133 vss 0.06272f
C1846 vdd.t175 vss 1.05949f
C1847 vdd.t174 vss 0.67069f
C1848 vdd.t130 vss 0.39674f
C1849 vdd.t131 vss 0.05758f
C1850 vdd.t173 vss 0.06685f
C1851 vdd.t172 vss 0.36157f
C1852 vdd.t125 vss 1.6156f
C1853 vdd.t126 vss 2.57998f
C1854 vdd.t219 vss 2.86956f
C1855 vdd.t218 vss 1.82592f
C1856 vdd.t180 vss 0.40835f
C1857 vdd.t181 vss 0.93036f
C1858 vdd.t233 vss 0.07215f
C1859 vdd.t232 vss 0.06272f
C1860 vdd.t178 vss 0.06685f
C1861 vdd.t179 vss 0.05758f
C1862 vdd.t231 vss 0.06685f
C1863 vdd.t230 vss 0.05758f
C1864 vdd.t115 vss 2.12003f
C1865 vdd.t116 vss 1.24791f
C1866 vdd.t16 vss 2.43323f
C1867 vdd.t15 vss 1.0756f
C1868 vdd.t113 vss 0.94353f
C1869 vdd.t114 vss 1.33419f
C1870 vdd.t14 vss 0.6832f
C1871 vdd.t13 vss 0.06272f
C1872 vdd.t163 vss 0.06685f
C1873 vdd.t164 vss 0.05758f
C1874 vdd.t94 vss 0.06685f
C1875 vdd.t93 vss 0.9394f
C1876 vdd.t161 vss 1.01477f
C1877 vdd.t162 vss 1.33979f
C1878 vdd.t2 vss 0.73679f
C1879 vdd.t1 vss 1.02721f
C1880 vdd.t159 vss 0.94267f
C1881 vdd.t160 vss 1.92074f
C1882 vdd.t10 vss 0.07215f
C1883 vdd.t9 vss 0.67347f
C1884 vdd.t242 vss 0.06685f
C1885 vdd.t243 vss 0.05758f
C1886 vdd.t8 vss 0.37222f
C1887 vdd.t7 vss 0.05758f
C1888 vdd.t89 vss 1.62417f
C1889 vdd.t92 vss 0.69802f
C1890 vdd.t4 vss 0.74174f
C1891 vdd.t3 vss 3.50431f
C1892 vdd.t90 vss 0.07215f
C1893 vdd.t91 vss 0.06272f
C1894 vdd.t194 vss 0.95391f
C1895 vdd.t193 vss 0.06272f
C1896 vdd.t212 vss 0.06685f
C1897 vdd.t213 vss 0.05758f
C1898 vdd.t247 vss 0.46356f
C1899 vdd.t246 vss 0.05758f
C1900 vdd.t157 vss 2.55726f
C1901 vdd.t158 vss 1.63815f
C1902 vdd.t171 vss 0.91228f
C1903 vdd.t170 vss 1.43935f
C1904 vdd.t235 vss 0.07215f
C1905 vdd.t236 vss 0.06272f
C1906 vdd.t111 vss 2.86488f
C1907 vdd.t110 vss 0.06272f
C1908 vdd.t288 vss 0.93607f
C1909 vdd.t289 vss 0.05758f
C1910 vdd.t109 vss 0.06685f
C1911 vdd.t108 vss 0.05758f
C1912 vdd.t208 vss 1.33389f
C1913 vdd.t211 vss 0.03173f
C1914 vdd.t12 vss 0.67774f
C1915 vdd.t11 vss 0.8207f
C1916 vdd.t209 vss 0.07215f
C1917 vdd.t210 vss 0.99927f
C1918 vdd.t88 vss 1.36756f
C1919 vdd.t87 vss 0.06272f
C1920 vdd.t238 vss 0.06685f
C1921 vdd.t239 vss 0.05758f
C1922 vdd.t86 vss 1.69437f
C1923 vdd.t85 vss 0.05758f
C1924 vdd.t137 vss 0.03373f
C1925 vdd.t138 vss 1.35128f
C1926 vdd.t98 vss 1.29816f
C1927 vdd.t97 vss 2.00642f
C1928 vdd.t220 vss 0.39878f
C1929 vdd.t221 vss 0.05758f
C1930 vdd.t146 vss 0.94565f
C1931 vdd.t145 vss 0.05758f
C1932 vdd.t153 vss 0.73602f
C1933 vdd.t154 vss 0.06272f
C1934 vdd.t148 vss 0.07215f
C1935 vdd.t147 vss 0.06272f
C1936 vdd.n60 vss 14.9225f
C1937 vdd.t31 vss 0.93451f
C1938 vdd.t27 vss 0.2119f
C1939 vdd.n61 vss 0.1525f
C1940 vdd.t25 vss 0.21664f
C1941 vdd.n62 vss 0.15598f
C1942 vdd.t22 vss 0.2119f
C1943 vdd.n63 vss 0.1525f
C1944 vdd.t34 vss 2.30626f
C1945 vdd.t21 vss 0.23391f
C1946 vdd.n64 vss 0.14055f
C1947 vdd.t17 vss 0.22034f
C1948 vdd.t23 vss 0.22923f
C1949 vdd.n65 vss 0.13554f
C1950 vdd.n66 vss 0.13554f
C1951 vdd.t26 vss 0.23391f
C1952 vdd.n67 vss 0.14055f
C1953 vdd.t24 vss 0.37091f
C1954 vdd.n68 vss 0.14067f
C1955 vdd.t29 vss 0.22923f
C1956 vdd.t32 vss 0.28733f
C1957 vdd.n69 vss 0.10768f
C1958 vdd.t18 vss 0.22986f
C1959 vdd.t28 vss 0.21664f
C1960 vdd.n70 vss 0.15598f
C1961 vdd.n71 vss 0.10448f
C1962 vdd.n72 vss 0.1525f
C1963 vdd.t30 vss 0.33035f
C1964 vbg.n0 vss 0.15022p
C1965 vbg.n1 vss 0.21352p
C1966 vbg.n2 vss 63.4638f
C1967 vbg.n3 vss 14.7646f
C1968 vbg.n4 vss 9.65938f
C1969 vbg.n5 vss 14.7689f
C1970 vbg.n6 vss 14.6884f
C1971 vbg.n7 vss 14.6946f
C1972 vbg.n8 vss 2.64787f
C1973 vbg.n9 vss 1.50783f
C1974 vbg.n10 vss 1.42452f
C1975 vbg.n11 vss 3.04861f
C1976 vbg.n12 vss 1.70492f
C1977 vbg.n13 vss 2.24014f
C1978 vbg.n14 vss 3.39364f
C1979 vbg.n15 vss 1.70219f
C1980 vbg.n16 vss 1.83583f
C1981 vbg.n17 vss 3.65271f
C1982 vbg.n18 vss 2.99615f
C1983 vbg.n19 vss 1.50136f
C1984 vbg.n20 vss 1.86445f
C1985 vbg.n21 vss 3.46229f
C1986 vbg.n22 vss 17.3459f
C1987 vbg.t5 vss 2.4462f
C1988 vbg.t1 vss 2.45471f
C1989 vbg.t7 vss 2.42247f
C1990 vbg.n23 vss 0.23065p
C1991 vbg.t0 vss 2.42175f
C1992 vbg.t4 vss 2.45294f
C1993 vbg.t3 vss 2.42613f
C1994 vbg.t2 vss 2.44544f
C1995 vbg.t6 vss 28.63087f
C1996 vbg.n24 vss 12.8253f
C1997 vbg.n25 vss 0.43787p
.ends
